* Extracted by KLayout with SG13G2 LVS runset on : 03/08/2026 14:37

.SUBCKT sg13g2_and2_1 A B VDD VSS X
M$1 \$5 A \$7 VSS sg13_lv_nmos L=0.13u W=0.64u AS=0.2176p AD=0.1216p PS=1.96u
+ PD=1.02u rfmode=0
M$2 VSS B \$7 VSS sg13_lv_nmos L=0.13u W=0.64u AS=0.1331p AD=0.1216p PS=1.12u
+ PD=1.02u rfmode=0
M$3 VSS \$5 X VSS sg13_lv_nmos L=0.13u W=0.74u AS=0.1331p AD=0.2516p PS=1.12u
+ PD=2.16u rfmode=0
M$4 VDD A \$5 VDD sg13_lv_pmos L=0.13u W=0.84u AS=0.2856p AD=0.1596p PS=2.36u
+ PD=1.22u rfmode=0
M$5 VDD B \$5 VDD sg13_lv_pmos L=0.13u W=0.84u AS=0.1918p AD=0.1596p PS=1.5u
+ PD=1.22u rfmode=0
M$6 VDD \$5 X VDD sg13_lv_pmos L=0.13u W=1.12u AS=0.1918p AD=0.3808p PS=1.5u
+ PD=2.92u rfmode=0
.ENDS sg13g2_and2_1
