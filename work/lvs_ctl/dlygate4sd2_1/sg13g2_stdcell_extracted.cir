* Extracted by KLayout with SG13G2 LVS runset on : 03/08/2026 15:22

.SUBCKT sg13g2_dlygate4sd2_1 A VDD VSS X
M$1 \$3 A VSS VSS sg13_lv_nmos L=0.13u W=0.42u AS=0.1428p AD=0.1323p PS=1.52u
+ PD=1.05u rfmode=0
M$2 VSS \$3 \$4 VSS sg13_lv_nmos L=0.18u W=0.42u AS=0.1323p AD=0.1428p PS=1.05u
+ PD=1.52u rfmode=0
M$3 VSS \$4 \$6 VSS sg13_lv_nmos L=0.18u W=0.42u AS=0.1405p AD=0.2163p PS=1.15u
+ PD=1.87u rfmode=0
M$4 VSS \$6 X VSS sg13_lv_nmos L=0.13u W=0.74u AS=0.1405p AD=0.2516p PS=1.15u
+ PD=2.16u rfmode=0
M$5 VDD A \$3 VDD sg13_lv_pmos L=0.13u W=0.42u AS=0.2481p AD=0.1428p PS=1.56u
+ PD=1.52u rfmode=0
M$6 VDD \$3 \$4 VDD sg13_lv_pmos L=0.25u W=1u AS=0.2481p AD=0.34p PS=1.56u
+ PD=2.68u rfmode=0
M$7 \$6 \$4 VDD VDD sg13_lv_pmos L=0.25u W=1u AS=0.445p AD=0.2245p PS=2.89u
+ PD=1.53u rfmode=0
M$8 VDD \$6 X VDD sg13_lv_pmos L=0.13u W=1.12u AS=0.2245p AD=0.3808p PS=1.53u
+ PD=2.92u rfmode=0
.ENDS sg13g2_dlygate4sd2_1
