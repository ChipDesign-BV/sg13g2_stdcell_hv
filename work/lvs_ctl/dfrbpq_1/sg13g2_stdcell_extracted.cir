* Extracted by KLayout with SG13G2 LVS runset on : 03/08/2026 15:22

.SUBCKT sg13g2_dfrbpq_1 CLK D Q RESET_B VDD VSS
M$1 \$5 D \$15 VSS sg13_lv_nmos L=0.13u W=0.42u AS=0.1428p AD=0.0609p PS=1.52u
+ PD=0.71u rfmode=0
M$2 \$15 RESET_B VSS VSS sg13_lv_nmos L=0.13u W=0.42u AS=0.0609p AD=0.1626p
+ PS=0.71u PD=1.415u rfmode=0
M$3 VSS \$12 \$3 VSS sg13_lv_nmos L=0.13u W=0.74u AS=0.1626p AD=0.2516p
+ PS=1.415u PD=2.16u rfmode=0
M$4 \$7 \$8 VSS VSS sg13_lv_nmos L=0.13u W=0.42u AS=0.1428p AD=0.0798p PS=1.52u
+ PD=0.8u rfmode=0
M$5 VSS RESET_B \$16 VSS sg13_lv_nmos L=0.13u W=0.42u AS=0.0798p AD=0.0378p
+ PS=0.8u PD=0.6u rfmode=0
M$6 \$16 \$14 \$8 VSS sg13_lv_nmos L=0.13u W=0.42u AS=0.0378p AD=0.1428p
+ PS=0.6u PD=1.52u rfmode=0
M$7 VSS RESET_B \$17 VSS sg13_lv_nmos L=0.13u W=0.42u AS=0.1701p AD=0.0378p
+ PS=1.65u PD=0.6u rfmode=0
M$8 \$17 \$3 \$6 VSS sg13_lv_nmos L=0.13u W=0.42u AS=0.0378p AD=0.1428p PS=0.6u
+ PD=1.52u rfmode=0
M$9 \$9 \$14 VSS VSS sg13_lv_nmos L=0.13u W=0.74u AS=0.2516p AD=0.1406p
+ PS=2.16u PD=1.12u rfmode=0
M$10 VSS \$9 Q VSS sg13_lv_nmos L=0.13u W=0.74u AS=0.1406p AD=0.2516p PS=1.12u
+ PD=2.16u rfmode=0
M$11 \$14 \$4 \$7 VSS sg13_lv_nmos L=0.13u W=0.42u AS=0.12665p AD=0.1428p
+ PS=1.145u PD=1.52u rfmode=0
M$12 \$3 \$19 \$14 VSS sg13_lv_nmos L=0.13u W=0.74u AS=0.3473p AD=0.12665p
+ PS=2.71u PD=1.145u rfmode=0
M$13 VSS \$4 \$19 VSS sg13_lv_nmos L=0.13u W=0.74u AS=0.317325p AD=0.2516p
+ PS=1.805u PD=2.16u rfmode=0
M$14 VSS CLK \$4 VSS sg13_lv_nmos L=0.13u W=0.74u AS=0.317325p AD=0.2516p
+ PS=1.805u PD=2.16u rfmode=0
M$15 \$5 \$4 \$12 VSS sg13_lv_nmos L=0.13u W=0.42u AS=0.1296p AD=0.0798p
+ PS=1.52u PD=0.8u rfmode=0
M$16 \$12 \$19 \$6 VSS sg13_lv_nmos L=0.13u W=0.42u AS=0.0798p AD=0.2373p
+ PS=0.8u PD=1.97u rfmode=0
M$17 \$14 \$19 \$21 VDD sg13_lv_pmos L=0.13u W=0.42u AS=0.2048p AD=0.09345p
+ PS=1.63u PD=0.865u rfmode=0
M$18 \$21 \$8 VDD VDD sg13_lv_pmos L=0.13u W=0.42u AS=0.09345p AD=0.204p
+ PS=0.865u PD=1.835u rfmode=0
M$19 VDD RESET_B \$8 VDD sg13_lv_pmos L=0.13u W=0.42u AS=0.204p AD=0.0798p
+ PS=1.835u PD=0.8u rfmode=0
M$20 \$8 \$14 VDD VDD sg13_lv_pmos L=0.13u W=0.42u AS=0.0798p AD=0.4659p
+ PS=0.8u PD=3.65u rfmode=0
M$21 \$3 \$4 \$14 VDD sg13_lv_pmos L=0.13u W=1u AS=0.34p AD=0.2048p PS=2.68u
+ PD=1.63u rfmode=0
M$22 VDD D \$5 VDD sg13_lv_pmos L=0.13u W=0.42u AS=0.1428p AD=0.0798p PS=1.52u
+ PD=0.8u rfmode=0
M$23 VDD RESET_B \$5 VDD sg13_lv_pmos L=0.13u W=0.42u AS=0.3623875p AD=0.0798p
+ PS=2.605u PD=0.8u rfmode=0
M$24 VDD \$12 \$3 VDD sg13_lv_pmos L=0.13u W=1u AS=0.3623875p AD=0.34p
+ PS=2.605u PD=2.68u rfmode=0
M$25 \$12 RESET_B VDD VDD sg13_lv_pmos L=0.13u W=0.42u AS=0.147p AD=0.1563p
+ PS=1.54u PD=1.22u rfmode=0
M$26 VDD \$3 \$20 VDD sg13_lv_pmos L=0.13u W=0.42u AS=0.1563p AD=0.063p
+ PS=1.22u PD=0.72u rfmode=0
M$27 \$20 \$4 \$12 VDD sg13_lv_pmos L=0.13u W=0.42u AS=0.063p AD=0.0798p
+ PS=0.72u PD=0.8u rfmode=0
M$28 \$12 \$19 \$5 VDD sg13_lv_pmos L=0.13u W=0.42u AS=0.0798p AD=0.1428p
+ PS=0.8u PD=1.52u rfmode=0
M$29 \$19 \$4 VDD VDD sg13_lv_pmos L=0.13u W=1.12u AS=0.3864p AD=0.41165p
+ PS=2.93u PD=2.12u rfmode=0
M$30 VDD CLK \$4 VDD sg13_lv_pmos L=0.13u W=1.12u AS=0.41165p AD=0.4088p
+ PS=2.12u PD=2.97u rfmode=0
M$31 \$9 \$14 VDD VDD sg13_lv_pmos L=0.13u W=1.12u AS=0.3864p AD=0.2128p
+ PS=2.93u PD=1.5u rfmode=0
M$32 VDD \$9 Q VDD sg13_lv_pmos L=0.13u W=1.12u AS=0.2128p AD=0.3808p PS=1.5u
+ PD=2.92u rfmode=0
.ENDS sg13g2_dfrbpq_1
