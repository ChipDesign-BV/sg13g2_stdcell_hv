* Extracted by KLayout with SG13G2 LVS runset on : 03/08/2026 15:22

.SUBCKT sg13g2_dfrbp_1 CLK D Q Q_N RESET_B VDD VSS
M$1 \$5 D \$16 VSS sg13_lv_nmos L=0.13u W=0.42u AS=0.1428p AD=0.0609p PS=1.52u
+ PD=0.71u rfmode=0
M$2 \$16 RESET_B VSS VSS sg13_lv_nmos L=0.13u W=0.42u AS=0.0609p AD=0.1626p
+ PS=0.71u PD=1.415u rfmode=0
M$3 VSS \$12 \$3 VSS sg13_lv_nmos L=0.13u W=0.74u AS=0.1626p AD=0.2516p
+ PS=1.415u PD=2.16u rfmode=0
M$4 \$7 \$15 VSS VSS sg13_lv_nmos L=0.13u W=0.42u AS=0.1428p AD=0.0798p
+ PS=1.52u PD=0.8u rfmode=0
M$5 VSS RESET_B \$18 VSS sg13_lv_nmos L=0.13u W=0.42u AS=0.0798p AD=0.0378p
+ PS=0.8u PD=0.6u rfmode=0
M$6 \$18 \$14 \$15 VSS sg13_lv_nmos L=0.13u W=0.42u AS=0.0378p AD=0.1428p
+ PS=0.6u PD=1.52u rfmode=0
M$7 VSS RESET_B \$17 VSS sg13_lv_nmos L=0.13u W=0.42u AS=0.1701p AD=0.0378p
+ PS=1.65u PD=0.6u rfmode=0
M$8 \$17 \$3 \$6 VSS sg13_lv_nmos L=0.13u W=0.42u AS=0.0378p AD=0.1428p PS=0.6u
+ PD=1.52u rfmode=0
M$9 VSS \$14 Q_N VSS sg13_lv_nmos L=0.13u W=0.74u AS=0.2516p AD=0.2849p
+ PS=2.16u PD=2.25u rfmode=0
M$10 \$9 \$14 VSS VSS sg13_lv_nmos L=0.13u W=0.74u AS=0.2516p AD=0.1406p
+ PS=2.16u PD=1.12u rfmode=0
M$11 VSS \$9 Q VSS sg13_lv_nmos L=0.13u W=0.74u AS=0.1406p AD=0.2516p PS=1.12u
+ PD=2.16u rfmode=0
M$12 \$14 \$4 \$7 VSS sg13_lv_nmos L=0.13u W=0.42u AS=0.12665p AD=0.1428p
+ PS=1.145u PD=1.52u rfmode=0
M$13 \$3 \$20 \$14 VSS sg13_lv_nmos L=0.13u W=0.74u AS=0.3473p AD=0.12665p
+ PS=2.71u PD=1.145u rfmode=0
M$14 VSS \$4 \$20 VSS sg13_lv_nmos L=0.13u W=0.74u AS=0.317325p AD=0.2516p
+ PS=1.805u PD=2.16u rfmode=0
M$15 VSS CLK \$4 VSS sg13_lv_nmos L=0.13u W=0.74u AS=0.317325p AD=0.2516p
+ PS=1.805u PD=2.16u rfmode=0
M$16 \$5 \$4 \$12 VSS sg13_lv_nmos L=0.13u W=0.42u AS=0.1296p AD=0.0798p
+ PS=1.52u PD=0.8u rfmode=0
M$17 \$12 \$20 \$6 VSS sg13_lv_nmos L=0.13u W=0.42u AS=0.0798p AD=0.2373p
+ PS=0.8u PD=1.97u rfmode=0
M$18 \$14 \$20 \$22 VDD sg13_lv_pmos L=0.13u W=0.42u AS=0.2048p AD=0.09345p
+ PS=1.63u PD=0.865u rfmode=0
M$19 \$22 \$15 VDD VDD sg13_lv_pmos L=0.13u W=0.42u AS=0.09345p AD=0.204p
+ PS=0.865u PD=1.835u rfmode=0
M$20 VDD RESET_B \$15 VDD sg13_lv_pmos L=0.13u W=0.42u AS=0.204p AD=0.0798p
+ PS=1.835u PD=0.8u rfmode=0
M$21 VDD \$14 \$15 VDD sg13_lv_pmos L=0.13u W=0.42u AS=0.2639p AD=0.0798p
+ PS=1.81u PD=0.8u rfmode=0
M$22 \$3 \$4 \$14 VDD sg13_lv_pmos L=0.13u W=1u AS=0.34p AD=0.2048p PS=2.68u
+ PD=1.63u rfmode=0
M$23 VDD \$14 Q_N VDD sg13_lv_pmos L=0.13u W=1.12u AS=0.2639p AD=0.4312p
+ PS=1.81u PD=3.01u rfmode=0
M$24 VDD D \$5 VDD sg13_lv_pmos L=0.13u W=0.42u AS=0.1428p AD=0.0798p PS=1.52u
+ PD=0.8u rfmode=0
M$25 VDD RESET_B \$5 VDD sg13_lv_pmos L=0.13u W=0.42u AS=0.3623875p AD=0.0798p
+ PS=2.605u PD=0.8u rfmode=0
M$26 VDD \$12 \$3 VDD sg13_lv_pmos L=0.13u W=1u AS=0.3623875p AD=0.34p
+ PS=2.605u PD=2.68u rfmode=0
M$27 \$12 RESET_B VDD VDD sg13_lv_pmos L=0.13u W=0.42u AS=0.147p AD=0.1563p
+ PS=1.54u PD=1.22u rfmode=0
M$28 VDD \$3 \$21 VDD sg13_lv_pmos L=0.13u W=0.42u AS=0.1563p AD=0.063p
+ PS=1.22u PD=0.72u rfmode=0
M$29 \$21 \$4 \$12 VDD sg13_lv_pmos L=0.13u W=0.42u AS=0.063p AD=0.0798p
+ PS=0.72u PD=0.8u rfmode=0
M$30 \$12 \$20 \$5 VDD sg13_lv_pmos L=0.13u W=0.42u AS=0.0798p AD=0.1428p
+ PS=0.8u PD=1.52u rfmode=0
M$31 \$20 \$4 VDD VDD sg13_lv_pmos L=0.13u W=1.12u AS=0.3864p AD=0.41165p
+ PS=2.93u PD=2.12u rfmode=0
M$32 VDD CLK \$4 VDD sg13_lv_pmos L=0.13u W=1.12u AS=0.41165p AD=0.4088p
+ PS=2.12u PD=2.97u rfmode=0
M$33 \$9 \$14 VDD VDD sg13_lv_pmos L=0.13u W=1.12u AS=0.3864p AD=0.2128p
+ PS=2.93u PD=1.5u rfmode=0
M$34 VDD \$9 Q VDD sg13_lv_pmos L=0.13u W=1.12u AS=0.2128p AD=0.3808p PS=1.5u
+ PD=2.92u rfmode=0
.ENDS sg13g2_dfrbp_1
