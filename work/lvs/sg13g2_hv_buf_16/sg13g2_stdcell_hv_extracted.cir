* Extracted by KLayout with SG13G2 LVS runset on : 04/08/2026 18:19

.SUBCKT sg13g2_hv_buf_16 A VDD VSS X
M$1 VSS \$2 X VSS sg13_hv_nmos L=0.45u W=11.84u AS=2.3606p AD=2.2496p PS=18.96u
+ PD=17.92u rfmode=0
M$17 VSS A \$2 VSS sg13_hv_nmos L=0.45u W=4.44u AS=0.8436p AD=0.9546p PS=6.72u
+ PD=7.76u rfmode=0
M$23 VDD \$2 X VDD sg13_hv_pmos L=0.45u W=43.04u AS=8.62145p AD=8.1776p
+ PS=52.14u PD=49.12u rfmode=0
M$39 VDD A \$2 VDD sg13_hv_pmos L=0.45u W=16.14u AS=3.0666p AD=3.4701p
+ PS=18.42u PD=21.41u rfmode=0
.ENDS sg13g2_hv_buf_16
