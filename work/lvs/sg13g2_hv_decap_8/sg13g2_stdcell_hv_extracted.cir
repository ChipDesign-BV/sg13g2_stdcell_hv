* Extracted by KLayout with SG13G2 LVS runset on : 04/08/2026 18:20

.SUBCKT sg13g2_hv_decap_8 VDD VSS
M$1 VSS VDD VSS VSS sg13_hv_nmos L=1u W=0.84u AS=0.2226p AD=0.2226p PS=2.32u
+ PD=2.32u rfmode=0
M$3 VDD VSS VDD VDD sg13_hv_pmos L=1u W=4.8u AS=1.272p AD=1.272p PS=8.26u
+ PD=8.26u rfmode=0
.ENDS sg13g2_hv_decap_8
