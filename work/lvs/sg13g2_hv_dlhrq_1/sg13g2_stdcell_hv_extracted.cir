* Extracted by KLayout with SG13G2 LVS runset on : 04/08/2026 18:20

.SUBCKT sg13g2_hv_dlhrq_1 D GATE Q RESET_B VDD VSS
M$1 \$5 \$3 \$10 VSS sg13_hv_nmos L=0.45u W=0.42u AS=0.20095p AD=0.0525p
+ PS=1.335u PD=0.67u rfmode=0
M$2 \$10 \$6 VSS VSS sg13_hv_nmos L=0.45u W=0.42u AS=0.0525p AD=0.3318p
+ PS=0.67u PD=2.42u rfmode=0
M$3 VSS \$2 \$9 VSS sg13_hv_nmos L=0.45u W=0.64u AS=0.1393p AD=0.096p PS=1.155u
+ PD=0.94u rfmode=0
M$4 \$9 \$4 \$5 VSS sg13_hv_nmos L=0.45u W=0.64u AS=0.096p AD=0.20095p PS=0.94u
+ PD=1.335u rfmode=0
M$5 VSS \$3 \$4 VSS sg13_hv_nmos L=0.45u W=0.74u AS=0.1393p AD=0.3828p
+ PS=1.155u PD=2.8u rfmode=0
M$6 VSS D \$2 VSS sg13_hv_nmos L=0.45u W=0.55u AS=0.3578p AD=0.43175p PS=1.725u
+ PD=2.67u rfmode=0
M$7 VSS GATE \$3 VSS sg13_hv_nmos L=0.45u W=0.74u AS=0.3578p AD=0.2516p
+ PS=1.725u PD=2.16u rfmode=0
M$8 \$6 \$5 \$8 VSS sg13_hv_nmos L=0.45u W=0.74u AS=0.3441p AD=0.0925p PS=2.41u
+ PD=0.99u rfmode=0
M$9 \$8 RESET_B VSS VSS sg13_hv_nmos L=0.45u W=0.74u AS=0.0925p AD=0.222p
+ PS=0.99u PD=1.34u rfmode=0
M$10 VSS \$6 Q VSS sg13_hv_nmos L=0.45u W=0.74u AS=0.222p AD=0.4181p PS=1.34u
+ PD=2.61u rfmode=0
M$11 VDD \$3 \$4 VDD sg13_hv_pmos L=0.45u W=2.015u AS=0.5759375p AD=0.6851p
+ PS=2.9u PD=4.71u rfmode=0
M$12 VDD \$2 \$15 VDD sg13_hv_pmos L=0.45u W=2.4u AS=0.5759375p AD=0.426p
+ PS=2.9u PD=2.755u rfmode=0
M$13 \$15 \$3 \$5 VDD sg13_hv_pmos L=0.45u W=2.4u AS=0.426p AD=0.45535p
+ PS=2.755u PD=2.82u rfmode=0
M$14 \$5 \$4 \$16 VDD sg13_hv_pmos L=0.45u W=1.01u AS=0.45535p AD=0.5656p
+ PS=2.82u PD=2.13u rfmode=0
M$15 VDD \$6 \$16 VDD sg13_hv_pmos L=0.45u W=1.01u AS=0.484325p AD=0.5656p
+ PS=3.015u PD=2.13u rfmode=0
M$16 VDD \$5 \$6 VDD sg13_hv_pmos L=0.45u W=2.4u AS=0.484325p AD=0.882p
+ PS=3.015u PD=3.135u rfmode=0
M$17 VDD RESET_B \$6 VDD sg13_hv_pmos L=0.45u W=2.4u AS=0.791975p AD=0.882p
+ PS=3.295u PD=3.135u rfmode=0
M$18 VDD \$6 Q VDD sg13_hv_pmos L=0.45u W=2.69u AS=0.791975p AD=1.0491p
+ PS=3.295u PD=6.16u rfmode=0
M$19 \$2 D VDD VDD sg13_hv_pmos L=0.45u W=2.015u AS=0.6851p AD=0.6196125p
+ PS=4.71u PD=2.63u rfmode=0
M$20 \$3 GATE VDD VDD sg13_hv_pmos L=0.45u W=2.015u AS=2.3003p AD=0.6196125p
+ PS=7u PD=2.63u rfmode=0
.ENDS sg13g2_hv_dlhrq_1
