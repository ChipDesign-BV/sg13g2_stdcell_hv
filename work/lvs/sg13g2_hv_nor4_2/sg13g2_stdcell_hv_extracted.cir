* Extracted by KLayout with SG13G2 LVS runset on : 04/08/2026 18:23

.SUBCKT sg13g2_hv_nor4_2 A B C D VDD VSS Y
M$1 VSS A Y VSS sg13_hv_nmos L=0.45u W=1.48u AS=0.3959p AD=0.4699p PS=3.29u
+ PD=2.75u rfmode=0
M$3 VSS B Y VSS sg13_hv_nmos L=0.45u W=1.48u AS=0.4699p AD=0.2812p PS=2.75u
+ PD=2.24u rfmode=0
M$5 VSS C Y VSS sg13_hv_nmos L=0.45u W=1.48u AS=0.2812p AD=0.4699p PS=2.24u
+ PD=2.75u rfmode=0
M$7 VSS D Y VSS sg13_hv_nmos L=0.45u W=1.48u AS=0.4699p AD=0.3922p PS=2.75u
+ PD=3.28u rfmode=0
M$9 VDD A \$8 VDD sg13_hv_pmos L=0.45u W=5.38u AS=1.43915p AD=1.4257p PS=9.14u
+ PD=9.13u rfmode=0
M$11 \$10 B \$8 VDD sg13_hv_pmos L=0.45u W=5.38u AS=1.4257p AD=1.0222p PS=9.13u
+ PD=6.14u rfmode=0
M$13 \$10 C \$9 VDD sg13_hv_pmos L=0.45u W=5.38u AS=1.0222p AD=1.4257p PS=6.14u
+ PD=9.13u rfmode=0
M$15 \$9 D Y VDD sg13_hv_pmos L=0.45u W=5.38u AS=1.4257p AD=1.4257p PS=9.13u
+ PD=9.13u rfmode=0
.ENDS sg13g2_hv_nor4_2
