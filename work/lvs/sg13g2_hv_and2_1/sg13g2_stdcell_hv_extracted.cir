* Extracted by KLayout with SG13G2 LVS runset on : 04/08/2026 18:19

.SUBCKT sg13g2_hv_and2_1 A B VDD VSS X
M$1 \$6 A \$7 VSS sg13_hv_nmos L=0.45u W=0.64u AS=0.2176p AD=0.1216p PS=1.96u
+ PD=1.02u rfmode=0
M$2 VSS B \$7 VSS sg13_hv_nmos L=0.45u W=0.64u AS=0.1331p AD=0.1216p PS=1.12u
+ PD=1.02u rfmode=0
M$3 VSS \$6 X VSS sg13_hv_nmos L=0.45u W=0.74u AS=0.1331p AD=0.2516p PS=1.12u
+ PD=2.16u rfmode=0
M$4 VDD A \$6 VDD sg13_hv_pmos L=0.45u W=2.015u AS=0.6851p AD=0.38285p PS=4.71u
+ PD=2.395u rfmode=0
M$5 VDD B \$6 VDD sg13_hv_pmos L=0.45u W=2.015u AS=0.460475p AD=0.38285p
+ PS=3.07u PD=2.395u rfmode=0
M$6 VDD \$6 X VDD sg13_hv_pmos L=0.45u W=2.69u AS=0.460475p AD=0.9146p PS=3.07u
+ PD=6.06u rfmode=0
.ENDS sg13g2_hv_and2_1
