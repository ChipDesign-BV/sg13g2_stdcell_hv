* Extracted by KLayout with SG13G2 LVS runset on : 04/08/2026 18:23

.SUBCKT sg13g2_hv_sdfbbp_1 CLK D Q Q_N RESET_B SCD SCE SET_B VDD VSS
M$1 \$19 \$5 \$25 VSS sg13_hv_nmos L=0.45u W=0.42u AS=0.3252125p AD=0.1029p
+ PS=1.735u PD=0.91u rfmode=0
M$2 \$25 \$26 VSS VSS sg13_hv_nmos L=0.45u W=0.42u AS=0.1029p AD=0.1442p
+ PS=0.91u PD=1.16u rfmode=0
M$3 VSS SET_B \$7 VSS sg13_hv_nmos L=0.45u W=0.74u AS=0.1442p AD=0.1406p
+ PS=1.16u PD=1.12u rfmode=0
M$4 \$7 \$19 \$26 VSS sg13_hv_nmos L=0.45u W=0.74u AS=0.1406p AD=0.34965p
+ PS=1.12u PD=1.685u rfmode=0
M$5 \$26 \$18 \$7 VSS sg13_hv_nmos L=0.45u W=0.74u AS=0.34965p AD=0.2516p
+ PS=1.685u PD=2.16u rfmode=0
M$6 VSS \$16 \$24 VSS sg13_hv_nmos L=0.45u W=0.55u AS=0.20075p AD=0.06875p
+ PS=1.83u PD=0.8u rfmode=0
M$7 \$19 \$15 \$24 VSS sg13_hv_nmos L=0.45u W=0.55u AS=0.3252125p AD=0.06875p
+ PS=1.735u PD=0.8u rfmode=0
M$8 \$4 \$5 \$6 VSS sg13_hv_nmos L=0.45u W=0.42u AS=0.1428p AD=0.1365p PS=1.52u
+ PD=1.07u rfmode=0
M$9 \$6 \$15 \$23 VSS sg13_hv_nmos L=0.45u W=0.42u AS=0.1365p AD=0.1617625p
+ PS=1.07u PD=1.23u rfmode=0
M$10 VSS \$16 \$23 VSS sg13_hv_nmos L=0.45u W=0.42u AS=0.19065p AD=0.1617625p
+ PS=1.43u PD=1.23u rfmode=0
M$11 \$3 \$6 \$16 VSS sg13_hv_nmos L=0.45u W=0.55u AS=0.2008125p AD=0.26125p
+ PS=1.385u PD=1.5u rfmode=0
M$12 \$3 \$18 \$16 VSS sg13_hv_nmos L=0.45u W=0.55u AS=0.35175p AD=0.26125p
+ PS=2.62u PD=1.5u rfmode=0
M$13 VSS SET_B \$3 VSS sg13_hv_nmos L=0.45u W=0.55u AS=0.19065p AD=0.2008125p
+ PS=1.43u PD=1.385u rfmode=0
M$14 \$9 \$26 VSS VSS sg13_hv_nmos L=0.45u W=0.55u AS=0.187p AD=0.19685p
+ PS=1.78u PD=1.29u rfmode=0
M$15 VSS \$9 Q VSS sg13_hv_nmos L=0.45u W=0.74u AS=0.19685p AD=0.2516p PS=1.29u
+ PD=2.16u rfmode=0
M$16 VSS SCD \$21 VSS sg13_hv_nmos L=0.45u W=0.42u AS=0.1428p AD=0.0798p
+ PS=1.52u PD=0.8u rfmode=0
M$17 \$21 SCE \$4 VSS sg13_hv_nmos L=0.45u W=0.42u AS=0.0798p AD=0.0798p
+ PS=0.8u PD=0.8u rfmode=0
M$18 \$4 D \$22 VSS sg13_hv_nmos L=0.45u W=0.42u AS=0.0798p AD=0.05985p PS=0.8u
+ PD=0.705u rfmode=0
M$19 \$22 \$13 VSS VSS sg13_hv_nmos L=0.45u W=0.42u AS=0.05985p AD=0.2436p
+ PS=0.705u PD=1.58u rfmode=0
M$20 VSS SCE \$13 VSS sg13_hv_nmos L=0.45u W=0.42u AS=0.2436p AD=0.1743p
+ PS=1.58u PD=1.67u rfmode=0
M$21 VSS RESET_B \$18 VSS sg13_hv_nmos L=0.45u W=0.42u AS=0.1254p AD=0.1533p
+ PS=1.12u PD=1.57u rfmode=0
M$22 VSS \$26 Q_N VSS sg13_hv_nmos L=0.45u W=0.74u AS=0.1254p AD=0.2886p
+ PS=1.12u PD=2.26u rfmode=0
M$23 VSS CLK \$5 VSS sg13_hv_nmos L=0.45u W=0.74u AS=0.6992p AD=0.2516p
+ PS=2.68u PD=2.16u rfmode=0
M$24 VSS \$5 \$15 VSS sg13_hv_nmos L=0.45u W=0.74u AS=0.6992p AD=0.6216p
+ PS=2.68u PD=3.16u rfmode=0
M$25 VDD RESET_B \$18 VDD sg13_hv_pmos L=0.45u W=1.535u AS=0.5974625p
+ AD=0.5526p PS=3.175u PD=3.79u rfmode=0
M$26 VDD \$26 Q_N VDD sg13_hv_pmos L=0.45u W=2.69u AS=0.5974625p AD=0.9146p
+ PS=3.175u PD=6.06u rfmode=0
M$27 \$6 \$5 \$30 VDD sg13_hv_pmos L=0.45u W=1.01u AS=0.3951875p AD=0.12625p
+ PS=2.19u PD=1.26u rfmode=0
M$28 VDD \$16 \$30 VDD sg13_hv_pmos L=0.45u W=1.01u AS=0.4876p AD=0.12625p
+ PS=2.61u PD=1.26u rfmode=0
M$29 \$6 \$15 \$4 VDD sg13_hv_pmos L=0.45u W=1.535u AS=0.3951875p AD=0.93635p
+ PS=2.19u PD=4.29u rfmode=0
M$30 VDD SET_B \$16 VDD sg13_hv_pmos L=0.45u W=2.015u AS=0.4876p AD=1.2493p
+ PS=2.61u PD=3.255u rfmode=0
M$31 \$16 \$6 \$31 VDD sg13_hv_pmos L=0.45u W=2.015u AS=1.2493p AD=0.4281875p
+ PS=3.255u PD=2.44u rfmode=0
M$32 \$31 \$18 VDD VDD sg13_hv_pmos L=0.45u W=2.015u AS=0.4281875p AD=0.38285p
+ PS=2.44u PD=2.395u rfmode=0
M$33 VDD \$16 \$32 VDD sg13_hv_pmos L=0.45u W=2.015u AS=0.38285p AD=0.4475125p
+ PS=2.395u PD=2.92u rfmode=0
M$34 \$32 \$5 \$19 VDD sg13_hv_pmos L=0.45u W=2.015u AS=0.4475125p AD=0.8944p
+ PS=2.92u PD=3u rfmode=0
M$35 \$19 \$15 \$34 VDD sg13_hv_pmos L=0.45u W=1.01u AS=0.8944p AD=0.209575p
+ PS=3u PD=1.425u rfmode=0
M$36 VDD \$26 \$34 VDD sg13_hv_pmos L=0.45u W=1.01u AS=0.9583875p AD=0.209575p
+ PS=3.925u PD=1.425u rfmode=0
M$37 VDD SET_B \$26 VDD sg13_hv_pmos L=0.45u W=2.4u AS=0.9583875p AD=0.87p
+ PS=3.925u PD=3.125u rfmode=0
M$38 \$26 \$19 \$33 VDD sg13_hv_pmos L=0.45u W=2.4u AS=0.87p AD=0.3p PS=3.125u
+ PD=2.65u rfmode=0
M$39 \$33 \$18 VDD VDD sg13_hv_pmos L=0.45u W=2.4u AS=0.3p AD=1.44p PS=2.65u
+ PD=6u rfmode=0
M$40 \$28 SCD VDD VDD sg13_hv_pmos L=0.45u W=1.535u AS=0.5219p AD=0.29165p
+ PS=3.75u PD=1.915u rfmode=0
M$41 VDD SCE \$29 VDD sg13_hv_pmos L=0.45u W=1.535u AS=0.29165p AD=0.3185125p
+ PS=1.915u PD=1.95u rfmode=0
M$42 \$29 D \$4 VDD sg13_hv_pmos L=0.45u W=1.535u AS=0.3185125p AD=0.729125p
+ PS=1.95u PD=2.485u rfmode=0
M$43 \$4 \$13 \$28 VDD sg13_hv_pmos L=0.45u W=1.535u AS=0.729125p AD=0.5219p
+ PS=2.485u PD=3.75u rfmode=0
M$44 VDD SCE \$13 VDD sg13_hv_pmos L=0.45u W=1.535u AS=0.637025p AD=0.5219p
+ PS=3.9u PD=3.75u rfmode=0
M$45 \$5 CLK VDD VDD sg13_hv_pmos L=0.45u W=2.69u AS=1.11635p AD=1.27775p
+ PS=6.21u PD=3.64u rfmode=0
M$46 VDD \$5 \$15 VDD sg13_hv_pmos L=0.45u W=2.69u AS=1.27775p AD=0.95495p
+ PS=3.64u PD=6.09u rfmode=0
M$47 VDD \$26 \$9 VDD sg13_hv_pmos L=0.45u W=2.015u AS=0.460475p AD=0.6851p
+ PS=3.07u PD=4.71u rfmode=0
M$48 VDD \$9 Q VDD sg13_hv_pmos L=0.45u W=2.69u AS=0.460475p AD=1.2374p
+ PS=3.07u PD=6.3u rfmode=0
.ENDS sg13g2_hv_sdfbbp_1
