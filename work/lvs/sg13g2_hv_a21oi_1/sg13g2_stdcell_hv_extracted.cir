* Extracted by KLayout with SG13G2 LVS runset on : 04/08/2026 18:18

.SUBCKT sg13g2_hv_a21oi_1 A1 A2 B1 VDD VSS Y
M$1 VSS B1 Y VSS sg13_hv_nmos L=0.45u W=0.74u AS=0.2516p AD=0.1406p PS=2.16u
+ PD=1.12u rfmode=0
M$2 Y A1 \$8 VSS sg13_hv_nmos L=0.45u W=0.74u AS=0.1406p AD=0.1406p PS=1.12u
+ PD=1.12u rfmode=0
M$3 \$8 A2 VSS VSS sg13_hv_nmos L=0.45u W=0.74u AS=0.1406p AD=0.2516p PS=1.12u
+ PD=2.16u rfmode=0
M$4 Y B1 \$7 VDD sg13_hv_pmos L=0.45u W=2.69u AS=0.9146p AD=0.5111p PS=6.06u
+ PD=3.07u rfmode=0
M$5 \$7 A1 VDD VDD sg13_hv_pmos L=0.45u W=2.69u AS=0.5111p AD=0.5111p PS=3.07u
+ PD=3.07u rfmode=0
M$6 VDD A2 \$7 VDD sg13_hv_pmos L=0.45u W=2.69u AS=0.5111p AD=0.9146p PS=3.07u
+ PD=6.06u rfmode=0
.ENDS sg13g2_hv_a21oi_1
