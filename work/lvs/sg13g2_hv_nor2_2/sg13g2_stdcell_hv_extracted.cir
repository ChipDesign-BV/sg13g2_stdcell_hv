* Extracted by KLayout with SG13G2 LVS runset on : 04/08/2026 18:22

.SUBCKT sg13g2_hv_nor2_2 A B VDD VSS Y
M$1 VSS A Y VSS sg13_hv_nmos L=0.45u W=1.48u AS=0.3922p AD=0.2812p PS=3.28u
+ PD=2.24u rfmode=0
M$3 VSS B Y VSS sg13_hv_nmos L=0.45u W=1.48u AS=0.2812p AD=0.3922p PS=2.24u
+ PD=3.28u rfmode=0
M$5 \$6 A VDD VDD sg13_hv_pmos L=0.45u W=5.38u AS=1.4795p AD=1.0222p PS=9.17u
+ PD=6.14u rfmode=0
M$7 \$6 B Y VDD sg13_hv_pmos L=0.45u W=5.38u AS=1.0222p AD=1.4257p PS=6.14u
+ PD=9.13u rfmode=0
.ENDS sg13g2_hv_nor2_2
