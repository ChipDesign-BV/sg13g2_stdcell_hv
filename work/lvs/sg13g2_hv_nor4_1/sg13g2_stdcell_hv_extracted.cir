* Extracted by KLayout with SG13G2 LVS runset on : 04/08/2026 18:22

.SUBCKT sg13g2_hv_nor4_1 A B C D VDD VSS Y
M$1 VSS A Y VSS sg13_hv_nmos L=0.45u W=0.74u AS=0.2516p AD=0.1406p PS=2.16u
+ PD=1.12u rfmode=0
M$2 Y B VSS VSS sg13_hv_nmos L=0.45u W=0.74u AS=0.1406p AD=0.1406p PS=1.12u
+ PD=1.12u rfmode=0
M$3 VSS C Y VSS sg13_hv_nmos L=0.45u W=0.74u AS=0.1406p AD=0.1406p PS=1.12u
+ PD=1.12u rfmode=0
M$4 Y D VSS VSS sg13_hv_nmos L=0.45u W=0.74u AS=0.1406p AD=0.237575p PS=1.12u
+ PD=2.16u rfmode=0
M$5 VDD A \$8 VDD sg13_hv_pmos L=0.45u W=2.69u AS=0.9146p AD=0.5111p PS=6.06u
+ PD=3.07u rfmode=0
M$6 \$8 B \$9 VDD sg13_hv_pmos L=0.45u W=2.69u AS=0.5111p AD=0.5111p PS=3.07u
+ PD=3.07u rfmode=0
M$7 \$9 C \$10 VDD sg13_hv_pmos L=0.45u W=2.69u AS=0.5111p AD=0.5111p PS=3.07u
+ PD=3.07u rfmode=0
M$8 \$10 D Y VDD sg13_hv_pmos L=0.45u W=2.69u AS=0.5111p AD=1.0491p PS=3.07u
+ PD=6.16u rfmode=0
.ENDS sg13g2_hv_nor4_1
