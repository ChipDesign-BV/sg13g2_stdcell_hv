* Extracted by KLayout with SG13G2 LVS runset on : 04/08/2026 18:18

.SUBCKT sg13g2_hv_a221oi_1 A1 A2 B1 B2 C1 VDD VSS Y
M$1 Y C1 VSS VSS sg13_hv_nmos L=0.45u W=0.74u AS=0.2516p AD=0.1406p PS=2.16u
+ PD=1.12u rfmode=0
M$2 VSS B2 \$11 VSS sg13_hv_nmos L=0.45u W=0.74u AS=0.1406p AD=0.1406p PS=1.12u
+ PD=1.12u rfmode=0
M$3 \$11 B1 Y VSS sg13_hv_nmos L=0.45u W=0.74u AS=0.1406p AD=0.2516p PS=1.12u
+ PD=2.16u rfmode=0
M$4 Y A1 \$12 VSS sg13_hv_nmos L=0.45u W=0.74u AS=0.2516p AD=0.1406p PS=2.16u
+ PD=1.12u rfmode=0
M$5 \$12 A2 VSS VSS sg13_hv_nmos L=0.45u W=0.74u AS=0.1406p AD=0.2516p PS=1.12u
+ PD=2.16u rfmode=0
M$6 Y C1 \$10 VDD sg13_hv_pmos L=0.45u W=2.69u AS=0.9146p AD=0.5111p PS=6.06u
+ PD=3.07u rfmode=0
M$7 \$10 B2 \$9 VDD sg13_hv_pmos L=0.45u W=2.69u AS=0.5111p AD=0.5111p PS=3.07u
+ PD=3.07u rfmode=0
M$8 \$9 B1 \$10 VDD sg13_hv_pmos L=0.45u W=2.69u AS=0.5111p AD=0.9146p PS=3.07u
+ PD=6.06u rfmode=0
M$9 VDD A1 \$9 VDD sg13_hv_pmos L=0.45u W=2.69u AS=0.9146p AD=0.5111p PS=6.06u
+ PD=3.07u rfmode=0
M$10 \$9 A2 VDD VDD sg13_hv_pmos L=0.45u W=2.69u AS=0.5111p AD=0.9146p PS=3.07u
+ PD=6.06u rfmode=0
.ENDS sg13g2_hv_a221oi_1
