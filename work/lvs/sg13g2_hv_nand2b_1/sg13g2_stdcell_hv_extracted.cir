* Extracted by KLayout with SG13G2 LVS runset on : 04/08/2026 18:22

.SUBCKT sg13g2_hv_nand2b_1 A_N B VDD VSS Y
M$1 VSS A_N \$4 VSS sg13_hv_nmos L=0.45u W=0.55u AS=0.14505p AD=0.187p PS=1.15u
+ PD=1.78u rfmode=0
M$2 VSS B \$7 VSS sg13_hv_nmos L=0.45u W=0.74u AS=0.14505p AD=0.1406p PS=1.15u
+ PD=1.12u rfmode=0
M$3 \$7 \$4 Y VSS sg13_hv_nmos L=0.45u W=0.74u AS=0.1406p AD=0.333p PS=1.12u
+ PD=2.38u rfmode=0
M$4 VDD A_N \$4 VDD sg13_hv_pmos L=0.45u W=2.015u AS=0.527825p AD=0.6851p
+ PS=3.1u PD=4.71u rfmode=0
M$5 VDD B Y VDD sg13_hv_pmos L=0.45u W=2.69u AS=0.527825p AD=0.5111p PS=3.1u
+ PD=3.07u rfmode=0
M$6 Y \$4 VDD VDD sg13_hv_pmos L=0.45u W=2.69u AS=0.5111p AD=0.9146p PS=3.07u
+ PD=6.06u rfmode=0
.ENDS sg13g2_hv_nand2b_1
