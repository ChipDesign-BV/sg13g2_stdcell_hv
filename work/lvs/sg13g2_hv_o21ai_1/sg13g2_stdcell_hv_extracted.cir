* Extracted by KLayout with SG13G2 LVS runset on : 04/08/2026 18:23

.SUBCKT sg13g2_hv_o21ai_1 A1 A2 B1 VDD VSS Y
M$1 \$3 A1 VSS VSS sg13_hv_nmos L=0.45u W=0.74u AS=0.2516p AD=0.1406p PS=2.16u
+ PD=1.12u rfmode=0
M$2 VSS A2 \$3 VSS sg13_hv_nmos L=0.45u W=0.74u AS=0.1406p AD=0.1406p PS=1.12u
+ PD=1.12u rfmode=0
M$3 \$3 B1 Y VSS sg13_hv_nmos L=0.45u W=0.74u AS=0.1406p AD=0.2516p PS=1.12u
+ PD=2.16u rfmode=0
M$4 VDD A1 \$8 VDD sg13_hv_pmos L=0.45u W=2.69u AS=0.9146p AD=0.5111p PS=6.06u
+ PD=3.07u rfmode=0
M$5 \$8 A2 Y VDD sg13_hv_pmos L=0.45u W=2.69u AS=0.5111p AD=0.5111p PS=3.07u
+ PD=3.07u rfmode=0
M$6 Y B1 VDD VDD sg13_hv_pmos L=0.45u W=2.69u AS=0.5111p AD=0.9146p PS=3.07u
+ PD=6.06u rfmode=0
.ENDS sg13g2_hv_o21ai_1
