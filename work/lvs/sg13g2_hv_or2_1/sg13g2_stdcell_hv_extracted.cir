* Extracted by KLayout with SG13G2 LVS runset on : 04/08/2026 18:23

.SUBCKT sg13g2_hv_or2_1 A B VDD VSS X
M$1 VSS B \$4 VSS sg13_hv_nmos L=0.45u W=0.55u AS=0.187p AD=0.1045p PS=1.78u
+ PD=0.93u rfmode=0
M$2 \$4 A VSS VSS sg13_hv_nmos L=0.45u W=0.55u AS=0.1045p AD=0.1469p PS=0.93u
+ PD=1.155u rfmode=0
M$3 VSS \$4 X VSS sg13_hv_nmos L=0.45u W=0.74u AS=0.1469p AD=0.2516p PS=1.155u
+ PD=2.16u rfmode=0
M$4 \$4 B \$7 VDD sg13_hv_pmos L=0.45u W=2.015u AS=0.6851p AD=0.38285p PS=4.71u
+ PD=2.395u rfmode=0
M$5 VDD A \$7 VDD sg13_hv_pmos L=0.45u W=2.015u AS=0.53455p AD=0.38285p
+ PS=3.105u PD=2.395u rfmode=0
M$6 VDD \$4 X VDD sg13_hv_pmos L=0.45u W=2.69u AS=0.53455p AD=0.95495p
+ PS=3.105u PD=6.09u rfmode=0
.ENDS sg13g2_hv_or2_1
