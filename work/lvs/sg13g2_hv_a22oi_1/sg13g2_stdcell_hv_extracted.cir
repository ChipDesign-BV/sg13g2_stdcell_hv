* Extracted by KLayout with SG13G2 LVS runset on : 04/08/2026 18:18

.SUBCKT sg13g2_hv_a22oi_1 A1 A2 B1 B2 VDD VSS Y
M$1 VSS B1 \$9 VSS sg13_hv_nmos L=0.45u W=0.74u AS=0.2553p AD=0.13875p PS=2.17u
+ PD=1.115u rfmode=0
M$2 \$9 B2 Y VSS sg13_hv_nmos L=0.45u W=0.74u AS=0.13875p AD=0.5402p PS=1.115u
+ PD=2.2u rfmode=0
M$3 Y A1 \$10 VSS sg13_hv_nmos L=0.45u W=0.74u AS=0.5402p AD=0.0962p PS=2.2u
+ PD=1u rfmode=0
M$4 \$10 A2 VSS VSS sg13_hv_nmos L=0.45u W=0.74u AS=0.0962p AD=0.2516p PS=1u
+ PD=2.16u rfmode=0
M$5 VDD A1 \$8 VDD sg13_hv_pmos L=0.45u W=2.69u AS=0.9146p AD=1.015475p
+ PS=6.06u PD=3.445u rfmode=0
M$6 \$8 B1 Y VDD sg13_hv_pmos L=0.45u W=2.69u AS=1.015475p AD=0.5111p PS=3.445u
+ PD=3.07u rfmode=0
M$7 Y B2 \$8 VDD sg13_hv_pmos L=0.45u W=2.69u AS=0.5111p AD=1.2912p PS=3.07u
+ PD=3.65u rfmode=0
M$8 \$8 A2 VDD VDD sg13_hv_pmos L=0.45u W=2.69u AS=1.2912p AD=0.9146p PS=3.65u
+ PD=6.06u rfmode=0
.ENDS sg13g2_hv_a22oi_1
