* Extracted by KLayout with SG13G2 LVS runset on : 04/08/2026 18:23

.SUBCKT sg13g2_hv_xnor2_1 A B VDD VSS Y
M$1 VSS A \$3 VSS sg13_hv_nmos L=0.45u W=0.74u AS=0.406p AD=0.2516p PS=1.875u
+ PD=2.16u rfmode=0
M$2 VSS B \$3 VSS sg13_hv_nmos L=0.45u W=0.74u AS=0.406p AD=0.3515p PS=1.875u
+ PD=1.69u rfmode=0
M$3 \$3 \$4 Y VSS sg13_hv_nmos L=0.45u W=0.74u AS=0.3515p AD=0.2516p PS=1.69u
+ PD=2.16u rfmode=0
M$4 VSS A \$8 VSS sg13_hv_nmos L=0.45u W=0.64u AS=0.2272p AD=0.304p PS=1.99u
+ PD=1.59u rfmode=0
M$5 \$8 B \$4 VSS sg13_hv_nmos L=0.45u W=0.64u AS=0.304p AD=0.4608p PS=1.59u
+ PD=2.72u rfmode=0
M$6 VDD A \$4 VDD sg13_hv_pmos L=0.45u W=2.015u AS=2.125825p AD=0.957125p
+ PS=6.14u PD=2.965u rfmode=0
M$7 VDD B \$4 VDD sg13_hv_pmos L=0.45u W=2.015u AS=0.6940625p AD=0.957125p
+ PS=3.265u PD=2.965u rfmode=0
M$8 VDD A \$9 VDD sg13_hv_pmos L=0.45u W=2.69u AS=0.6940625p AD=0.342975p
+ PS=3.265u PD=2.945u rfmode=0
M$9 \$9 B Y VDD sg13_hv_pmos L=0.45u W=2.69u AS=0.342975p AD=1.27775p PS=2.945u
+ PD=3.64u rfmode=0
M$10 Y \$4 VDD VDD sg13_hv_pmos L=0.45u W=2.69u AS=1.27775p AD=2.43445p
+ PS=3.64u PD=7.19u rfmode=0
.ENDS sg13g2_hv_xnor2_1
