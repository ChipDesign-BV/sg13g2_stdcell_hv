* Extracted by KLayout with SG13G2 LVS runset on : 04/08/2026 18:19

.SUBCKT sg13g2_hv_and2_2 A B VDD VSS X
M$1 \$5 A \$7 VSS sg13_hv_nmos L=0.45u W=0.64u AS=0.2176p AD=0.1216p PS=1.96u
+ PD=1.02u rfmode=0
M$2 VSS B \$7 VSS sg13_hv_nmos L=0.45u W=0.64u AS=0.1331p AD=0.1216p PS=1.12u
+ PD=1.02u rfmode=0
M$3 VSS \$5 X VSS sg13_hv_nmos L=0.45u W=1.48u AS=0.2737p AD=0.4218p PS=2.24u
+ PD=3.36u rfmode=0
M$5 VDD A \$5 VDD sg13_hv_pmos L=0.45u W=2.015u AS=0.6851p AD=0.38285p PS=4.71u
+ PD=2.395u rfmode=0
M$6 VDD B \$5 VDD sg13_hv_pmos L=0.45u W=2.015u AS=0.460475p AD=0.38285p
+ PS=3.07u PD=2.395u rfmode=0
M$7 VDD \$5 X VDD sg13_hv_pmos L=0.45u W=5.38u AS=0.971575p AD=1.5333p PS=6.14u
+ PD=9.21u rfmode=0
.ENDS sg13g2_hv_and2_2
