* Extracted by KLayout with SG13G2 LVS runset on : 04/08/2026 18:22

.SUBCKT sg13g2_hv_nor2_1 A B VDD VSS Y
M$1 VSS A Y VSS sg13_hv_nmos L=0.45u W=0.74u AS=0.2516p AD=0.3515p PS=2.16u
+ PD=1.69u rfmode=0
M$2 Y B VSS VSS sg13_hv_nmos L=0.45u W=0.74u AS=0.3515p AD=0.2516p PS=1.69u
+ PD=2.16u rfmode=0
M$3 VDD A \$6 VDD sg13_hv_pmos L=0.45u W=2.69u AS=0.9684p AD=0.33625p PS=6.1u
+ PD=2.94u rfmode=0
M$4 \$6 B Y VDD sg13_hv_pmos L=0.45u W=2.69u AS=0.33625p AD=2.3403p PS=2.94u
+ PD=7.12u rfmode=0
.ENDS sg13g2_hv_nor2_1
