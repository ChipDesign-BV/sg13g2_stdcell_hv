* Extracted by KLayout with SG13G2 LVS runset on : 04/08/2026 18:18

.SUBCKT sg13g2_hv_a21o_2 A1 A2 B1 VDD VSS X
M$1 VSS \$4 X VSS sg13_hv_nmos L=0.45u W=1.48u AS=0.3922p AD=0.3922p PS=3.28u
+ PD=3.28u rfmode=0
M$3 VSS B1 \$4 VSS sg13_hv_nmos L=0.45u W=0.74u AS=0.7733p AD=0.2553p PS=3.57u
+ PD=1.43u rfmode=0
M$4 \$4 A1 \$9 VSS sg13_hv_nmos L=0.45u W=0.74u AS=0.2553p AD=0.09435p PS=1.43u
+ PD=0.995u rfmode=0
M$5 \$9 A2 VSS VSS sg13_hv_nmos L=0.45u W=0.74u AS=0.09435p AD=0.2516p
+ PS=0.995u PD=2.16u rfmode=0
M$6 \$4 B1 \$8 VDD sg13_hv_pmos L=0.45u W=2.4u AS=0.84p AD=1.146p PS=5.5u
+ PD=3.355u rfmode=0
M$7 \$8 A1 VDD VDD sg13_hv_pmos L=0.45u W=2.4u AS=1.146p AD=0.828p PS=3.355u
+ PD=3.09u rfmode=0
M$8 VDD A2 \$8 VDD sg13_hv_pmos L=0.45u W=2.4u AS=0.828p AD=0.816p PS=3.09u
+ PD=5.48u rfmode=0
M$9 VDD \$4 X VDD sg13_hv_pmos L=0.45u W=5.38u AS=1.4257p AD=1.4257p PS=9.13u
+ PD=9.13u rfmode=0
.ENDS sg13g2_hv_a21o_2
