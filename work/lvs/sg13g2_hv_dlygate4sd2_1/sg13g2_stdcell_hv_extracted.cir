* Extracted by KLayout with SG13G2 LVS runset on : 04/08/2026 18:20

.SUBCKT sg13g2_hv_dlygate4sd2_1 A VDD VSS X
M$1 \$6 A VSS VSS sg13_hv_nmos L=0.45u W=0.42u AS=0.1428p AD=0.16065p PS=1.52u
+ PD=1.185u rfmode=0
M$2 VSS \$6 \$3 VSS sg13_hv_nmos L=0.45u W=0.42u AS=0.16065p AD=0.1617p
+ PS=1.185u PD=1.61u rfmode=0
M$3 VSS \$3 \$5 VSS sg13_hv_nmos L=0.45u W=0.42u AS=0.1405p AD=0.2604p PS=1.15u
+ PD=2.08u rfmode=0
M$4 VSS \$5 X VSS sg13_hv_nmos L=0.45u W=0.74u AS=0.1405p AD=0.2516p PS=1.15u
+ PD=2.16u rfmode=0
M$5 VDD A \$6 VDD sg13_hv_pmos L=0.45u W=1.01u AS=0.59555p AD=0.41915p PS=2.96u
+ PD=2.85u rfmode=0
M$6 VDD \$6 \$3 VDD sg13_hv_pmos L=0.625u W=2.4u AS=0.59555p AD=0.816p PS=2.96u
+ PD=5.48u rfmode=0
M$7 VDD \$3 \$5 VDD sg13_hv_pmos L=0.625u W=2.4u AS=0.539125p AD=1.068p PS=3.1u
+ PD=5.69u rfmode=0
M$8 VDD \$5 X VDD sg13_hv_pmos L=0.45u W=2.69u AS=0.539125p AD=0.9146p PS=3.1u
+ PD=6.06u rfmode=0
.ENDS sg13g2_hv_dlygate4sd2_1
