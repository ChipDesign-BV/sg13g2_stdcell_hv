* Extracted by KLayout with SG13G2 LVS runset on : 04/08/2026 18:23

.SUBCKT sg13g2_hv_xor2_1 A B VDD VSS X
M$1 VSS A \$4 VSS sg13_hv_nmos L=0.45u W=0.55u AS=0.671p AD=0.308p PS=3.54u
+ PD=1.67u rfmode=0
M$2 VSS B \$4 VSS sg13_hv_nmos L=0.45u W=0.55u AS=0.15245p AD=0.308p PS=1.17u
+ PD=1.67u rfmode=0
M$3 VSS A \$8 VSS sg13_hv_nmos L=0.45u W=0.74u AS=0.15245p AD=0.0925p PS=1.17u
+ PD=0.99u rfmode=0
M$4 \$8 B X VSS sg13_hv_nmos L=0.45u W=0.74u AS=0.0925p AD=0.37p PS=0.99u
+ PD=1.74u rfmode=0
M$5 X \$4 VSS VSS sg13_hv_nmos L=0.45u W=0.74u AS=0.37p AD=0.4551p PS=1.74u
+ PD=2.71u rfmode=0
M$6 VDD A \$9 VDD sg13_hv_pmos L=0.45u W=2.4u AS=0.864p AD=1.14p PS=5.52u
+ PD=3.35u rfmode=0
M$7 \$9 B \$4 VDD sg13_hv_pmos L=0.45u W=2.4u AS=1.14p AD=0.816p PS=3.35u
+ PD=5.48u rfmode=0
M$8 \$7 A VDD VDD sg13_hv_pmos L=0.45u W=2.69u AS=0.9146p AD=1.27775p PS=6.06u
+ PD=3.64u rfmode=0
M$9 VDD B \$7 VDD sg13_hv_pmos L=0.45u W=2.69u AS=1.27775p AD=0.773375p
+ PS=3.64u PD=3.265u rfmode=0
M$10 \$7 \$4 X VDD sg13_hv_pmos L=0.45u W=2.69u AS=0.773375p AD=0.9146p
+ PS=3.265u PD=6.06u rfmode=0
.ENDS sg13g2_hv_xor2_1
