* Extracted by KLayout with SG13G2 LVS runset on : 04/08/2026 18:18

.SUBCKT sg13g2_hv_a21o_1 A1 A2 B1 VDD VSS X
M$1 X \$4 VSS VSS sg13_hv_nmos L=0.45u W=0.74u AS=0.2351p AD=0.3393p PS=2.16u
+ PD=1.705u rfmode=0
M$2 VSS B1 \$4 VSS sg13_hv_nmos L=0.45u W=0.64u AS=0.3393p AD=0.2208p PS=1.705u
+ PD=1.33u rfmode=0
M$3 \$4 A1 \$9 VSS sg13_hv_nmos L=0.45u W=0.64u AS=0.2208p AD=0.0816p PS=1.33u
+ PD=0.895u rfmode=0
M$4 \$9 A2 VSS VSS sg13_hv_nmos L=0.45u W=0.64u AS=0.0816p AD=0.2176p PS=0.895u
+ PD=1.96u rfmode=0
M$5 X \$4 VDD VDD sg13_hv_pmos L=0.45u W=2.69u AS=0.9146p AD=0.9146p PS=6.06u
+ PD=6.06u rfmode=0
M$6 \$4 B1 \$8 VDD sg13_hv_pmos L=0.45u W=2.4u AS=1.344p AD=1.146p PS=5.92u
+ PD=3.355u rfmode=0
M$7 \$8 A1 VDD VDD sg13_hv_pmos L=0.45u W=2.4u AS=1.146p AD=0.828p PS=3.355u
+ PD=3.09u rfmode=0
M$8 VDD A2 \$8 VDD sg13_hv_pmos L=0.45u W=2.4u AS=0.828p AD=0.816p PS=3.09u
+ PD=5.48u rfmode=0
.ENDS sg13g2_hv_a21o_1
