* Extracted by KLayout with SG13G2 LVS runset on : 04/08/2026 18:23

.SUBCKT sg13g2_hv_or3_1 A B C VDD VSS X
M$1 \$3 C VSS VSS sg13_hv_nmos L=0.45u W=0.55u AS=0.187p AD=0.1045p PS=1.78u
+ PD=0.93u rfmode=0
M$2 VSS B \$3 VSS sg13_hv_nmos L=0.45u W=0.55u AS=0.1045p AD=0.286p PS=0.93u
+ PD=1.59u rfmode=0
M$3 \$3 A VSS VSS sg13_hv_nmos L=0.45u W=0.55u AS=0.286p AD=0.19315p PS=1.59u
+ PD=1.28u rfmode=0
M$4 VSS \$3 X VSS sg13_hv_nmos L=0.45u W=0.74u AS=0.19315p AD=0.2516p PS=1.28u
+ PD=2.16u rfmode=0
M$5 \$3 C \$8 VDD sg13_hv_pmos L=0.45u W=2.4u AS=0.816p AD=0.456p PS=5.48u
+ PD=2.78u rfmode=0
M$6 \$8 B \$9 VDD sg13_hv_pmos L=0.45u W=2.4u AS=0.456p AD=0.378p PS=2.78u
+ PD=2.715u rfmode=0
M$7 VDD A \$9 VDD sg13_hv_pmos L=0.45u W=2.4u AS=1.321225p AD=0.378p PS=3.73u
+ PD=2.715u rfmode=0
M$8 VDD \$3 X VDD sg13_hv_pmos L=0.45u W=2.69u AS=1.321225p AD=1.345p PS=3.73u
+ PD=6.38u rfmode=0
.ENDS sg13g2_hv_or3_1
