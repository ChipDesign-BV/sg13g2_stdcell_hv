* Extracted by KLayout with SG13G2 LVS runset on : 04/08/2026 18:19

.SUBCKT sg13g2_hv_and4_2 A B C D VDD VSS X
M$1 \$8 A \$9 VSS sg13_hv_nmos L=0.45u W=0.64u AS=0.2176p AD=0.1216p PS=1.96u
+ PD=1.02u rfmode=0
M$2 \$9 B \$10 VSS sg13_hv_nmos L=0.45u W=0.64u AS=0.1216p AD=0.1216p PS=1.02u
+ PD=1.02u rfmode=0
M$3 \$10 C \$11 VSS sg13_hv_nmos L=0.45u W=0.64u AS=0.1216p AD=0.1408p PS=1.02u
+ PD=1.08u rfmode=0
M$4 \$11 D VSS VSS sg13_hv_nmos L=0.45u W=0.64u AS=0.1408p AD=0.1447p PS=1.08u
+ PD=1.15u rfmode=0
M$5 VSS \$8 X VSS sg13_hv_nmos L=0.45u W=1.48u AS=0.3371p AD=0.555p PS=2.41u
+ PD=3.72u rfmode=0
M$7 VDD A \$8 VDD sg13_hv_pmos L=0.45u W=2.015u AS=0.6851p AD=0.38285p PS=4.71u
+ PD=2.395u rfmode=0
M$8 \$8 B VDD VDD sg13_hv_pmos L=0.45u W=2.015u AS=0.38285p AD=0.38285p
+ PS=2.395u PD=2.395u rfmode=0
M$9 VDD C \$8 VDD sg13_hv_pmos L=0.45u W=2.015u AS=0.38285p AD=0.4433p
+ PS=2.395u PD=2.455u rfmode=0
M$10 VDD D \$8 VDD sg13_hv_pmos L=0.45u W=2.015u AS=0.4907p AD=0.4433p PS=3.1u
+ PD=2.455u rfmode=0
M$11 VDD \$8 X VDD sg13_hv_pmos L=0.45u W=5.38u AS=1.1901p AD=2.0175p PS=6.31u
+ PD=9.57u rfmode=0
.ENDS sg13g2_hv_and4_2
