* Extracted by KLayout with SG13G2 LVS runset on : 04/08/2026 18:20

.SUBCKT sg13g2_hv_einvn_8 A TE_B VDD VSS Z
M$1 VSS TE_B \$2 VSS sg13_hv_nmos L=0.45u W=0.74u AS=0.259p AD=0.2516p PS=2.18u
+ PD=2.16u rfmode=0
M$2 \$5 \$2 VSS VSS sg13_hv_nmos L=0.45u W=5.92u AS=3.0303p AD=2.6011p
+ PS=14.85u PD=12.95u rfmode=0
M$10 \$5 A Z VSS sg13_hv_nmos L=0.45u W=5.92u AS=1.1248p AD=1.2358p PS=8.96u
+ PD=10u rfmode=0
M$18 VDD TE_B \$2 VDD sg13_hv_pmos L=0.45u W=2.69u AS=0.9146p AD=0.9415p
+ PS=6.06u PD=6.08u rfmode=0
M$19 \$7 TE_B VDD VDD sg13_hv_pmos L=0.45u W=21.52u AS=9.85885p AD=10.39685p
+ PS=31.54u PD=29.25u rfmode=0
M$27 \$7 A Z VDD sg13_hv_pmos L=0.45u W=21.52u AS=5.0303p AD=4.4923p PS=25.26u
+ PD=27.55u rfmode=0
.ENDS sg13g2_hv_einvn_8
