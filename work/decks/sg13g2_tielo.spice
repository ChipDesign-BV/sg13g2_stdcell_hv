* sg13g2_tielo: exhaustive vectors, thin-oxide vs thick-oxide
.lib /foss/pdks/ihp-sg13g2/libs.tech/ngspice/models/cornerMOSlv.lib mos_tt
.lib /foss/pdks/ihp-sg13g2/libs.tech/ngspice/models/cornerMOShv.lib mos_tt
.include /foss/pdks/ihp-sg13g2/libs.ref/sg13g2_stdcell/spice/sg13g2_stdcell.spice
.include /foss/designs/sg13g2_stdcell_hv/spice/sg13g2_stdcell_hv.spice

Vlv vlv 0 1.2
Vhv vhv 0 3.3
Vlvh vlvh 0 0.6
Vhvh vhvh 0 1.65

Xlv0 o_lv_0_L_LO vlv 0 sg13g2_tielo
Rklv0L_LO o_lv_0_L_LO vlvh 1G
Xhv0 o_hv_0_L_LO vhv 0 sg13g2_hv_tielo
Rkhv0L_LO o_hv_0_L_LO vhvh 1G

.control
op
print v(o_lv_0_L_LO)
print v(o_hv_0_L_LO)
quit
.endc
.end
