* sg13g2_a221oi_1: exhaustive vectors, thin-oxide vs thick-oxide
.lib /foss/pdks/ihp-sg13g2/libs.tech/ngspice/models/cornerMOSlv.lib mos_tt
.lib /foss/pdks/ihp-sg13g2/libs.tech/ngspice/models/cornerMOShv.lib mos_tt
.include /foss/pdks/ihp-sg13g2/libs.ref/sg13g2_stdcell/spice/sg13g2_stdcell.spice
.include /foss/designs/sg13g2_stdcell_hv/spice/sg13g2_stdcell_hv.spice

Vlv vlv 0 1.2
Vhv vhv 0 3.3
Vlvh vlvh 0 0.6
Vhvh vhvh 0 1.65

Xlv0 o_lv_0_Y 0 0 0 0 0 vlv 0 sg13g2_a221oi_1
Rklv0Y o_lv_0_Y vlvh 1G
Xhv0 o_hv_0_Y 0 0 0 0 0 vhv 0 sg13g2_hv_a221oi_1
Rkhv0Y o_hv_0_Y vhvh 1G
Xlv1 o_lv_1_Y 0 0 0 0 vlv vlv 0 sg13g2_a221oi_1
Rklv1Y o_lv_1_Y vlvh 1G
Xhv1 o_hv_1_Y 0 0 0 0 vhv vhv 0 sg13g2_hv_a221oi_1
Rkhv1Y o_hv_1_Y vhvh 1G
Xlv2 o_lv_2_Y 0 0 0 vlv 0 vlv 0 sg13g2_a221oi_1
Rklv2Y o_lv_2_Y vlvh 1G
Xhv2 o_hv_2_Y 0 0 0 vhv 0 vhv 0 sg13g2_hv_a221oi_1
Rkhv2Y o_hv_2_Y vhvh 1G
Xlv3 o_lv_3_Y 0 0 0 vlv vlv vlv 0 sg13g2_a221oi_1
Rklv3Y o_lv_3_Y vlvh 1G
Xhv3 o_hv_3_Y 0 0 0 vhv vhv vhv 0 sg13g2_hv_a221oi_1
Rkhv3Y o_hv_3_Y vhvh 1G
Xlv4 o_lv_4_Y 0 0 vlv 0 0 vlv 0 sg13g2_a221oi_1
Rklv4Y o_lv_4_Y vlvh 1G
Xhv4 o_hv_4_Y 0 0 vhv 0 0 vhv 0 sg13g2_hv_a221oi_1
Rkhv4Y o_hv_4_Y vhvh 1G
Xlv5 o_lv_5_Y 0 0 vlv 0 vlv vlv 0 sg13g2_a221oi_1
Rklv5Y o_lv_5_Y vlvh 1G
Xhv5 o_hv_5_Y 0 0 vhv 0 vhv vhv 0 sg13g2_hv_a221oi_1
Rkhv5Y o_hv_5_Y vhvh 1G
Xlv6 o_lv_6_Y 0 0 vlv vlv 0 vlv 0 sg13g2_a221oi_1
Rklv6Y o_lv_6_Y vlvh 1G
Xhv6 o_hv_6_Y 0 0 vhv vhv 0 vhv 0 sg13g2_hv_a221oi_1
Rkhv6Y o_hv_6_Y vhvh 1G
Xlv7 o_lv_7_Y 0 0 vlv vlv vlv vlv 0 sg13g2_a221oi_1
Rklv7Y o_lv_7_Y vlvh 1G
Xhv7 o_hv_7_Y 0 0 vhv vhv vhv vhv 0 sg13g2_hv_a221oi_1
Rkhv7Y o_hv_7_Y vhvh 1G
Xlv8 o_lv_8_Y 0 vlv 0 0 0 vlv 0 sg13g2_a221oi_1
Rklv8Y o_lv_8_Y vlvh 1G
Xhv8 o_hv_8_Y 0 vhv 0 0 0 vhv 0 sg13g2_hv_a221oi_1
Rkhv8Y o_hv_8_Y vhvh 1G
Xlv9 o_lv_9_Y 0 vlv 0 0 vlv vlv 0 sg13g2_a221oi_1
Rklv9Y o_lv_9_Y vlvh 1G
Xhv9 o_hv_9_Y 0 vhv 0 0 vhv vhv 0 sg13g2_hv_a221oi_1
Rkhv9Y o_hv_9_Y vhvh 1G
Xlv10 o_lv_10_Y 0 vlv 0 vlv 0 vlv 0 sg13g2_a221oi_1
Rklv10Y o_lv_10_Y vlvh 1G
Xhv10 o_hv_10_Y 0 vhv 0 vhv 0 vhv 0 sg13g2_hv_a221oi_1
Rkhv10Y o_hv_10_Y vhvh 1G
Xlv11 o_lv_11_Y 0 vlv 0 vlv vlv vlv 0 sg13g2_a221oi_1
Rklv11Y o_lv_11_Y vlvh 1G
Xhv11 o_hv_11_Y 0 vhv 0 vhv vhv vhv 0 sg13g2_hv_a221oi_1
Rkhv11Y o_hv_11_Y vhvh 1G
Xlv12 o_lv_12_Y 0 vlv vlv 0 0 vlv 0 sg13g2_a221oi_1
Rklv12Y o_lv_12_Y vlvh 1G
Xhv12 o_hv_12_Y 0 vhv vhv 0 0 vhv 0 sg13g2_hv_a221oi_1
Rkhv12Y o_hv_12_Y vhvh 1G
Xlv13 o_lv_13_Y 0 vlv vlv 0 vlv vlv 0 sg13g2_a221oi_1
Rklv13Y o_lv_13_Y vlvh 1G
Xhv13 o_hv_13_Y 0 vhv vhv 0 vhv vhv 0 sg13g2_hv_a221oi_1
Rkhv13Y o_hv_13_Y vhvh 1G
Xlv14 o_lv_14_Y 0 vlv vlv vlv 0 vlv 0 sg13g2_a221oi_1
Rklv14Y o_lv_14_Y vlvh 1G
Xhv14 o_hv_14_Y 0 vhv vhv vhv 0 vhv 0 sg13g2_hv_a221oi_1
Rkhv14Y o_hv_14_Y vhvh 1G
Xlv15 o_lv_15_Y 0 vlv vlv vlv vlv vlv 0 sg13g2_a221oi_1
Rklv15Y o_lv_15_Y vlvh 1G
Xhv15 o_hv_15_Y 0 vhv vhv vhv vhv vhv 0 sg13g2_hv_a221oi_1
Rkhv15Y o_hv_15_Y vhvh 1G
Xlv16 o_lv_16_Y vlv 0 0 0 0 vlv 0 sg13g2_a221oi_1
Rklv16Y o_lv_16_Y vlvh 1G
Xhv16 o_hv_16_Y vhv 0 0 0 0 vhv 0 sg13g2_hv_a221oi_1
Rkhv16Y o_hv_16_Y vhvh 1G
Xlv17 o_lv_17_Y vlv 0 0 0 vlv vlv 0 sg13g2_a221oi_1
Rklv17Y o_lv_17_Y vlvh 1G
Xhv17 o_hv_17_Y vhv 0 0 0 vhv vhv 0 sg13g2_hv_a221oi_1
Rkhv17Y o_hv_17_Y vhvh 1G
Xlv18 o_lv_18_Y vlv 0 0 vlv 0 vlv 0 sg13g2_a221oi_1
Rklv18Y o_lv_18_Y vlvh 1G
Xhv18 o_hv_18_Y vhv 0 0 vhv 0 vhv 0 sg13g2_hv_a221oi_1
Rkhv18Y o_hv_18_Y vhvh 1G
Xlv19 o_lv_19_Y vlv 0 0 vlv vlv vlv 0 sg13g2_a221oi_1
Rklv19Y o_lv_19_Y vlvh 1G
Xhv19 o_hv_19_Y vhv 0 0 vhv vhv vhv 0 sg13g2_hv_a221oi_1
Rkhv19Y o_hv_19_Y vhvh 1G
Xlv20 o_lv_20_Y vlv 0 vlv 0 0 vlv 0 sg13g2_a221oi_1
Rklv20Y o_lv_20_Y vlvh 1G
Xhv20 o_hv_20_Y vhv 0 vhv 0 0 vhv 0 sg13g2_hv_a221oi_1
Rkhv20Y o_hv_20_Y vhvh 1G
Xlv21 o_lv_21_Y vlv 0 vlv 0 vlv vlv 0 sg13g2_a221oi_1
Rklv21Y o_lv_21_Y vlvh 1G
Xhv21 o_hv_21_Y vhv 0 vhv 0 vhv vhv 0 sg13g2_hv_a221oi_1
Rkhv21Y o_hv_21_Y vhvh 1G
Xlv22 o_lv_22_Y vlv 0 vlv vlv 0 vlv 0 sg13g2_a221oi_1
Rklv22Y o_lv_22_Y vlvh 1G
Xhv22 o_hv_22_Y vhv 0 vhv vhv 0 vhv 0 sg13g2_hv_a221oi_1
Rkhv22Y o_hv_22_Y vhvh 1G
Xlv23 o_lv_23_Y vlv 0 vlv vlv vlv vlv 0 sg13g2_a221oi_1
Rklv23Y o_lv_23_Y vlvh 1G
Xhv23 o_hv_23_Y vhv 0 vhv vhv vhv vhv 0 sg13g2_hv_a221oi_1
Rkhv23Y o_hv_23_Y vhvh 1G
Xlv24 o_lv_24_Y vlv vlv 0 0 0 vlv 0 sg13g2_a221oi_1
Rklv24Y o_lv_24_Y vlvh 1G
Xhv24 o_hv_24_Y vhv vhv 0 0 0 vhv 0 sg13g2_hv_a221oi_1
Rkhv24Y o_hv_24_Y vhvh 1G
Xlv25 o_lv_25_Y vlv vlv 0 0 vlv vlv 0 sg13g2_a221oi_1
Rklv25Y o_lv_25_Y vlvh 1G
Xhv25 o_hv_25_Y vhv vhv 0 0 vhv vhv 0 sg13g2_hv_a221oi_1
Rkhv25Y o_hv_25_Y vhvh 1G
Xlv26 o_lv_26_Y vlv vlv 0 vlv 0 vlv 0 sg13g2_a221oi_1
Rklv26Y o_lv_26_Y vlvh 1G
Xhv26 o_hv_26_Y vhv vhv 0 vhv 0 vhv 0 sg13g2_hv_a221oi_1
Rkhv26Y o_hv_26_Y vhvh 1G
Xlv27 o_lv_27_Y vlv vlv 0 vlv vlv vlv 0 sg13g2_a221oi_1
Rklv27Y o_lv_27_Y vlvh 1G
Xhv27 o_hv_27_Y vhv vhv 0 vhv vhv vhv 0 sg13g2_hv_a221oi_1
Rkhv27Y o_hv_27_Y vhvh 1G
Xlv28 o_lv_28_Y vlv vlv vlv 0 0 vlv 0 sg13g2_a221oi_1
Rklv28Y o_lv_28_Y vlvh 1G
Xhv28 o_hv_28_Y vhv vhv vhv 0 0 vhv 0 sg13g2_hv_a221oi_1
Rkhv28Y o_hv_28_Y vhvh 1G
Xlv29 o_lv_29_Y vlv vlv vlv 0 vlv vlv 0 sg13g2_a221oi_1
Rklv29Y o_lv_29_Y vlvh 1G
Xhv29 o_hv_29_Y vhv vhv vhv 0 vhv vhv 0 sg13g2_hv_a221oi_1
Rkhv29Y o_hv_29_Y vhvh 1G
Xlv30 o_lv_30_Y vlv vlv vlv vlv 0 vlv 0 sg13g2_a221oi_1
Rklv30Y o_lv_30_Y vlvh 1G
Xhv30 o_hv_30_Y vhv vhv vhv vhv 0 vhv 0 sg13g2_hv_a221oi_1
Rkhv30Y o_hv_30_Y vhvh 1G
Xlv31 o_lv_31_Y vlv vlv vlv vlv vlv vlv 0 sg13g2_a221oi_1
Rklv31Y o_lv_31_Y vlvh 1G
Xhv31 o_hv_31_Y vhv vhv vhv vhv vhv vhv 0 sg13g2_hv_a221oi_1
Rkhv31Y o_hv_31_Y vhvh 1G

.control
op
print v(o_lv_0_Y)
print v(o_hv_0_Y)
print v(o_lv_1_Y)
print v(o_hv_1_Y)
print v(o_lv_2_Y)
print v(o_hv_2_Y)
print v(o_lv_3_Y)
print v(o_hv_3_Y)
print v(o_lv_4_Y)
print v(o_hv_4_Y)
print v(o_lv_5_Y)
print v(o_hv_5_Y)
print v(o_lv_6_Y)
print v(o_hv_6_Y)
print v(o_lv_7_Y)
print v(o_hv_7_Y)
print v(o_lv_8_Y)
print v(o_hv_8_Y)
print v(o_lv_9_Y)
print v(o_hv_9_Y)
print v(o_lv_10_Y)
print v(o_hv_10_Y)
print v(o_lv_11_Y)
print v(o_hv_11_Y)
print v(o_lv_12_Y)
print v(o_hv_12_Y)
print v(o_lv_13_Y)
print v(o_hv_13_Y)
print v(o_lv_14_Y)
print v(o_hv_14_Y)
print v(o_lv_15_Y)
print v(o_hv_15_Y)
print v(o_lv_16_Y)
print v(o_hv_16_Y)
print v(o_lv_17_Y)
print v(o_hv_17_Y)
print v(o_lv_18_Y)
print v(o_hv_18_Y)
print v(o_lv_19_Y)
print v(o_hv_19_Y)
print v(o_lv_20_Y)
print v(o_hv_20_Y)
print v(o_lv_21_Y)
print v(o_hv_21_Y)
print v(o_lv_22_Y)
print v(o_hv_22_Y)
print v(o_lv_23_Y)
print v(o_hv_23_Y)
print v(o_lv_24_Y)
print v(o_hv_24_Y)
print v(o_lv_25_Y)
print v(o_hv_25_Y)
print v(o_lv_26_Y)
print v(o_hv_26_Y)
print v(o_lv_27_Y)
print v(o_hv_27_Y)
print v(o_lv_28_Y)
print v(o_hv_28_Y)
print v(o_lv_29_Y)
print v(o_hv_29_Y)
print v(o_lv_30_Y)
print v(o_hv_30_Y)
print v(o_lv_31_Y)
print v(o_hv_31_Y)
quit
.endc
.end
