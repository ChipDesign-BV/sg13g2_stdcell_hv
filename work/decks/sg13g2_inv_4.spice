* sg13g2_inv_4: exhaustive vectors, thin-oxide vs thick-oxide
.lib /foss/pdks/ihp-sg13g2/libs.tech/ngspice/models/cornerMOSlv.lib mos_tt
.lib /foss/pdks/ihp-sg13g2/libs.tech/ngspice/models/cornerMOShv.lib mos_tt
.include /foss/pdks/ihp-sg13g2/libs.ref/sg13g2_stdcell/spice/sg13g2_stdcell.spice
.include /foss/designs/sg13g2_stdcell_hv/spice/sg13g2_stdcell_hv.spice

Vlv vlv 0 1.2
Vhv vhv 0 3.3
Vlvh vlvh 0 0.6
Vhvh vhvh 0 1.65

Xlv0 o_lv_0_Y 0 vlv 0 sg13g2_inv_4
Rklv0Y o_lv_0_Y vlvh 1G
Xhv0 o_hv_0_Y 0 vhv 0 sg13g2_hv_inv_4
Rkhv0Y o_hv_0_Y vhvh 1G
Xlv1 o_lv_1_Y vlv vlv 0 sg13g2_inv_4
Rklv1Y o_lv_1_Y vlvh 1G
Xhv1 o_hv_1_Y vhv vhv 0 sg13g2_hv_inv_4
Rkhv1Y o_hv_1_Y vhvh 1G

.control
op
print v(o_lv_0_Y)
print v(o_hv_0_Y)
print v(o_lv_1_Y)
print v(o_hv_1_Y)
quit
.endc
.end
