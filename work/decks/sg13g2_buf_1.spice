* sg13g2_buf_1: exhaustive vectors, thin-oxide vs thick-oxide
.lib /foss/pdks/ihp-sg13g2/libs.tech/ngspice/models/cornerMOSlv.lib mos_tt
.lib /foss/pdks/ihp-sg13g2/libs.tech/ngspice/models/cornerMOShv.lib mos_tt
.include /foss/pdks/ihp-sg13g2/libs.ref/sg13g2_stdcell/spice/sg13g2_stdcell.spice
.include /foss/designs/sg13g2_stdcell_hv/spice/sg13g2_stdcell_hv.spice

Vlv vlv 0 1.2
Vhv vhv 0 3.3
Vlvh vlvh 0 0.6
Vhvh vhvh 0 1.65

Xlv0 o_lv_0_X 0 vlv 0 sg13g2_buf_1
Rklv0X o_lv_0_X vlvh 1G
Xhv0 o_hv_0_X 0 vhv 0 sg13g2_hv_buf_1
Rkhv0X o_hv_0_X vhvh 1G
Xlv1 o_lv_1_X vlv vlv 0 sg13g2_buf_1
Rklv1X o_lv_1_X vlvh 1G
Xhv1 o_hv_1_X vhv vhv 0 sg13g2_hv_buf_1
Rkhv1X o_hv_1_X vhvh 1G

.control
op
print v(o_lv_0_X)
print v(o_hv_0_X)
print v(o_lv_1_X)
print v(o_hv_1_X)
quit
.endc
.end
