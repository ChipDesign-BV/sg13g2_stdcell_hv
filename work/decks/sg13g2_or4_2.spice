* sg13g2_or4_2: exhaustive vectors, thin-oxide vs thick-oxide
.lib /foss/pdks/ihp-sg13g2/libs.tech/ngspice/models/cornerMOSlv.lib mos_tt
.lib /foss/pdks/ihp-sg13g2/libs.tech/ngspice/models/cornerMOShv.lib mos_tt
.include /foss/pdks/ihp-sg13g2/libs.ref/sg13g2_stdcell/spice/sg13g2_stdcell.spice
.include /foss/designs/sg13g2_stdcell_hv/spice/sg13g2_stdcell_hv.spice

Vlv vlv 0 1.2
Vhv vhv 0 3.3
Vlvh vlvh 0 0.6
Vhvh vhvh 0 1.65

Xlv0 o_lv_0_X 0 0 0 0 vlv 0 sg13g2_or4_2
Rklv0X o_lv_0_X vlvh 1G
Xhv0 o_hv_0_X 0 0 0 0 vhv 0 sg13g2_hv_or4_2
Rkhv0X o_hv_0_X vhvh 1G
Xlv1 o_lv_1_X 0 0 0 vlv vlv 0 sg13g2_or4_2
Rklv1X o_lv_1_X vlvh 1G
Xhv1 o_hv_1_X 0 0 0 vhv vhv 0 sg13g2_hv_or4_2
Rkhv1X o_hv_1_X vhvh 1G
Xlv2 o_lv_2_X 0 0 vlv 0 vlv 0 sg13g2_or4_2
Rklv2X o_lv_2_X vlvh 1G
Xhv2 o_hv_2_X 0 0 vhv 0 vhv 0 sg13g2_hv_or4_2
Rkhv2X o_hv_2_X vhvh 1G
Xlv3 o_lv_3_X 0 0 vlv vlv vlv 0 sg13g2_or4_2
Rklv3X o_lv_3_X vlvh 1G
Xhv3 o_hv_3_X 0 0 vhv vhv vhv 0 sg13g2_hv_or4_2
Rkhv3X o_hv_3_X vhvh 1G
Xlv4 o_lv_4_X 0 vlv 0 0 vlv 0 sg13g2_or4_2
Rklv4X o_lv_4_X vlvh 1G
Xhv4 o_hv_4_X 0 vhv 0 0 vhv 0 sg13g2_hv_or4_2
Rkhv4X o_hv_4_X vhvh 1G
Xlv5 o_lv_5_X 0 vlv 0 vlv vlv 0 sg13g2_or4_2
Rklv5X o_lv_5_X vlvh 1G
Xhv5 o_hv_5_X 0 vhv 0 vhv vhv 0 sg13g2_hv_or4_2
Rkhv5X o_hv_5_X vhvh 1G
Xlv6 o_lv_6_X 0 vlv vlv 0 vlv 0 sg13g2_or4_2
Rklv6X o_lv_6_X vlvh 1G
Xhv6 o_hv_6_X 0 vhv vhv 0 vhv 0 sg13g2_hv_or4_2
Rkhv6X o_hv_6_X vhvh 1G
Xlv7 o_lv_7_X 0 vlv vlv vlv vlv 0 sg13g2_or4_2
Rklv7X o_lv_7_X vlvh 1G
Xhv7 o_hv_7_X 0 vhv vhv vhv vhv 0 sg13g2_hv_or4_2
Rkhv7X o_hv_7_X vhvh 1G
Xlv8 o_lv_8_X vlv 0 0 0 vlv 0 sg13g2_or4_2
Rklv8X o_lv_8_X vlvh 1G
Xhv8 o_hv_8_X vhv 0 0 0 vhv 0 sg13g2_hv_or4_2
Rkhv8X o_hv_8_X vhvh 1G
Xlv9 o_lv_9_X vlv 0 0 vlv vlv 0 sg13g2_or4_2
Rklv9X o_lv_9_X vlvh 1G
Xhv9 o_hv_9_X vhv 0 0 vhv vhv 0 sg13g2_hv_or4_2
Rkhv9X o_hv_9_X vhvh 1G
Xlv10 o_lv_10_X vlv 0 vlv 0 vlv 0 sg13g2_or4_2
Rklv10X o_lv_10_X vlvh 1G
Xhv10 o_hv_10_X vhv 0 vhv 0 vhv 0 sg13g2_hv_or4_2
Rkhv10X o_hv_10_X vhvh 1G
Xlv11 o_lv_11_X vlv 0 vlv vlv vlv 0 sg13g2_or4_2
Rklv11X o_lv_11_X vlvh 1G
Xhv11 o_hv_11_X vhv 0 vhv vhv vhv 0 sg13g2_hv_or4_2
Rkhv11X o_hv_11_X vhvh 1G
Xlv12 o_lv_12_X vlv vlv 0 0 vlv 0 sg13g2_or4_2
Rklv12X o_lv_12_X vlvh 1G
Xhv12 o_hv_12_X vhv vhv 0 0 vhv 0 sg13g2_hv_or4_2
Rkhv12X o_hv_12_X vhvh 1G
Xlv13 o_lv_13_X vlv vlv 0 vlv vlv 0 sg13g2_or4_2
Rklv13X o_lv_13_X vlvh 1G
Xhv13 o_hv_13_X vhv vhv 0 vhv vhv 0 sg13g2_hv_or4_2
Rkhv13X o_hv_13_X vhvh 1G
Xlv14 o_lv_14_X vlv vlv vlv 0 vlv 0 sg13g2_or4_2
Rklv14X o_lv_14_X vlvh 1G
Xhv14 o_hv_14_X vhv vhv vhv 0 vhv 0 sg13g2_hv_or4_2
Rkhv14X o_hv_14_X vhvh 1G
Xlv15 o_lv_15_X vlv vlv vlv vlv vlv 0 sg13g2_or4_2
Rklv15X o_lv_15_X vlvh 1G
Xhv15 o_hv_15_X vhv vhv vhv vhv vhv 0 sg13g2_hv_or4_2
Rkhv15X o_hv_15_X vhvh 1G

.control
op
print v(o_lv_0_X)
print v(o_hv_0_X)
print v(o_lv_1_X)
print v(o_hv_1_X)
print v(o_lv_2_X)
print v(o_hv_2_X)
print v(o_lv_3_X)
print v(o_hv_3_X)
print v(o_lv_4_X)
print v(o_hv_4_X)
print v(o_lv_5_X)
print v(o_hv_5_X)
print v(o_lv_6_X)
print v(o_hv_6_X)
print v(o_lv_7_X)
print v(o_hv_7_X)
print v(o_lv_8_X)
print v(o_hv_8_X)
print v(o_lv_9_X)
print v(o_hv_9_X)
print v(o_lv_10_X)
print v(o_hv_10_X)
print v(o_lv_11_X)
print v(o_hv_11_X)
print v(o_lv_12_X)
print v(o_hv_12_X)
print v(o_lv_13_X)
print v(o_hv_13_X)
print v(o_lv_14_X)
print v(o_hv_14_X)
print v(o_lv_15_X)
print v(o_hv_15_X)
quit
.endc
.end
