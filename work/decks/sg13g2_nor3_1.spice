* sg13g2_nor3_1: exhaustive vectors, thin-oxide vs thick-oxide
.lib /foss/pdks/ihp-sg13g2/libs.tech/ngspice/models/cornerMOSlv.lib mos_tt
.lib /foss/pdks/ihp-sg13g2/libs.tech/ngspice/models/cornerMOShv.lib mos_tt
.include /foss/pdks/ihp-sg13g2/libs.ref/sg13g2_stdcell/spice/sg13g2_stdcell.spice
.include /foss/designs/sg13g2_stdcell_hv/spice/sg13g2_stdcell_hv.spice

Vlv vlv 0 1.2
Vhv vhv 0 3.3
Vlvh vlvh 0 0.6
Vhvh vhvh 0 1.65

Xlv0 o_lv_0_Y 0 0 0 vlv 0 sg13g2_nor3_1
Rklv0Y o_lv_0_Y vlvh 1G
Xhv0 o_hv_0_Y 0 0 0 vhv 0 sg13g2_hv_nor3_1
Rkhv0Y o_hv_0_Y vhvh 1G
Xlv1 o_lv_1_Y 0 0 vlv vlv 0 sg13g2_nor3_1
Rklv1Y o_lv_1_Y vlvh 1G
Xhv1 o_hv_1_Y 0 0 vhv vhv 0 sg13g2_hv_nor3_1
Rkhv1Y o_hv_1_Y vhvh 1G
Xlv2 o_lv_2_Y 0 vlv 0 vlv 0 sg13g2_nor3_1
Rklv2Y o_lv_2_Y vlvh 1G
Xhv2 o_hv_2_Y 0 vhv 0 vhv 0 sg13g2_hv_nor3_1
Rkhv2Y o_hv_2_Y vhvh 1G
Xlv3 o_lv_3_Y 0 vlv vlv vlv 0 sg13g2_nor3_1
Rklv3Y o_lv_3_Y vlvh 1G
Xhv3 o_hv_3_Y 0 vhv vhv vhv 0 sg13g2_hv_nor3_1
Rkhv3Y o_hv_3_Y vhvh 1G
Xlv4 o_lv_4_Y vlv 0 0 vlv 0 sg13g2_nor3_1
Rklv4Y o_lv_4_Y vlvh 1G
Xhv4 o_hv_4_Y vhv 0 0 vhv 0 sg13g2_hv_nor3_1
Rkhv4Y o_hv_4_Y vhvh 1G
Xlv5 o_lv_5_Y vlv 0 vlv vlv 0 sg13g2_nor3_1
Rklv5Y o_lv_5_Y vlvh 1G
Xhv5 o_hv_5_Y vhv 0 vhv vhv 0 sg13g2_hv_nor3_1
Rkhv5Y o_hv_5_Y vhvh 1G
Xlv6 o_lv_6_Y vlv vlv 0 vlv 0 sg13g2_nor3_1
Rklv6Y o_lv_6_Y vlvh 1G
Xhv6 o_hv_6_Y vhv vhv 0 vhv 0 sg13g2_hv_nor3_1
Rkhv6Y o_hv_6_Y vhvh 1G
Xlv7 o_lv_7_Y vlv vlv vlv vlv 0 sg13g2_nor3_1
Rklv7Y o_lv_7_Y vlvh 1G
Xhv7 o_hv_7_Y vhv vhv vhv vhv 0 sg13g2_hv_nor3_1
Rkhv7Y o_hv_7_Y vhvh 1G

.control
op
print v(o_lv_0_Y)
print v(o_hv_0_Y)
print v(o_lv_1_Y)
print v(o_hv_1_Y)
print v(o_lv_2_Y)
print v(o_hv_2_Y)
print v(o_lv_3_Y)
print v(o_hv_3_Y)
print v(o_lv_4_Y)
print v(o_hv_4_Y)
print v(o_lv_5_Y)
print v(o_hv_5_Y)
print v(o_lv_6_Y)
print v(o_hv_6_Y)
print v(o_lv_7_Y)
print v(o_hv_7_Y)
quit
.endc
.end
