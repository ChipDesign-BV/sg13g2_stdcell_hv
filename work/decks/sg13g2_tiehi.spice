* sg13g2_tiehi: exhaustive vectors, thin-oxide vs thick-oxide
.lib /foss/pdks/ihp-sg13g2/libs.tech/ngspice/models/cornerMOSlv.lib mos_tt
.lib /foss/pdks/ihp-sg13g2/libs.tech/ngspice/models/cornerMOShv.lib mos_tt
.include /foss/pdks/ihp-sg13g2/libs.ref/sg13g2_stdcell/spice/sg13g2_stdcell.spice
.include /foss/designs/sg13g2_stdcell_hv/spice/sg13g2_stdcell_hv.spice

Vlv vlv 0 1.2
Vhv vhv 0 3.3
Vlvh vlvh 0 0.6
Vhvh vhvh 0 1.65

Xlv0 o_lv_0_L_HI vlv 0 sg13g2_tiehi
Rklv0L_HI o_lv_0_L_HI vlvh 1G
Xhv0 o_hv_0_L_HI vhv 0 sg13g2_hv_tiehi
Rkhv0L_HI o_hv_0_L_HI vhvh 1G

.control
op
print v(o_lv_0_L_HI)
print v(o_hv_0_L_HI)
quit
.endc
.end
