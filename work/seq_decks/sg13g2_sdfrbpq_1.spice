* sg13g2_sdfrbpq_1: sequential equivalence, thin-oxide vs thick-oxide
.lib /foss/pdks/ihp-sg13g2/libs.tech/ngspice/models/cornerMOSlv.lib mos_tt
.lib /foss/pdks/ihp-sg13g2/libs.tech/ngspice/models/cornerMOShv.lib mos_tt
.include /foss/pdks/ihp-sg13g2/libs.ref/sg13g2_stdcell/spice/sg13g2_stdcell.spice
.include /foss/designs/sg13g2_stdcell_hv/spice/sg13g2_stdcell_hv.spice

Vlvdd lvdd 0 1.2
Vlv_CLK i_lv_CLK 0 pulse(0 1.2 0 2e-10 2e-10 9.8e-09 2e-08)
Vlv_D i_lv_D 0 pwl(0 0 4.2e-08 0 4.22e-08 1.2 6.2e-08 1.2 6.22e-08 0 8.2e-08 0 8.22e-08 1.2 1.02e-07 1.2 1.022e-07 0 1.22e-07 0 1.222e-07 1.2 1.42e-07 1.2 1.422e-07 0 1.62e-07 0 1.622e-07 1.2 1.82e-07 1.2 1.822e-07 0 2.02e-07 0 2.022e-07 1.2 2.22e-07 1.2 2.222e-07 0 2.42e-07 0 2.422e-07 1.2 2.62e-07 1.2 2.622e-07 0 2.82e-07 0 2.822e-07 1.2 3.02e-07 1.2 3.022e-07 0 3.22e-07 0 3.222e-07 1.2 3.42e-07 1.2 3.422e-07 0 3.62e-07 0 3.622e-07 1.2 3.82e-07 1.2 3.822e-07 0 4.02e-07 0 4.022e-07 1.2 4.22e-07 1.2 4.222e-07 0 4.42e-07 0 4.422e-07 1.2 4.62e-07 1.2 4.622e-07 0 4.82e-07 0 4.822e-07 1.2 5.02e-07 1.2 5.022e-07 0 5.22e-07 0 5.222e-07 1.2 5.42e-07 1.2 5.422e-07 0 5.62e-07 0 5.622e-07 1.2 5.82e-07 1.2 5.822e-07 0 6.02e-07 0 6.022e-07 1.2 6.22e-07 1.2 6.222e-07 0 6.42e-07 0 6.422e-07 1.2)
Vlv_RESET_B i_lv_RESET_B 0 pwl(0 0 6.2e-08 0 6.22e-08 1.2 1.02e-07 1.2 1.022e-07 0 1.42e-07 0 1.422e-07 1.2 1.82e-07 1.2 1.822e-07 0 2.22e-07 0 2.222e-07 1.2 2.62e-07 1.2 2.622e-07 0 3.02e-07 0 3.022e-07 1.2 3.42e-07 1.2 3.422e-07 0 3.82e-07 0 3.822e-07 1.2 4.22e-07 1.2 4.222e-07 0 4.62e-07 0 4.622e-07 1.2 5.02e-07 1.2 5.022e-07 0 5.42e-07 0 5.422e-07 1.2 5.82e-07 1.2 5.822e-07 0 6.22e-07 0 6.222e-07 1.2)
Vlv_SCD i_lv_SCD 0 pwl(0 0 1.02e-07 0 1.022e-07 1.2 1.82e-07 1.2 1.822e-07 0 2.62e-07 0 2.622e-07 1.2 3.42e-07 1.2 3.422e-07 0 4.22e-07 0 4.222e-07 1.2 5.02e-07 1.2 5.022e-07 0 5.82e-07 0 5.822e-07 1.2)
Vlv_SCE i_lv_SCE 0 pwl(0 0 1.82e-07 0 1.822e-07 1.2 3.42e-07 1.2 3.422e-07 0 5.02e-07 0 5.022e-07 1.2)
Vhvdd hvdd 0 3.3
Vhv_CLK i_hv_CLK 0 pulse(0 3.3 0 2e-10 2e-10 9.8e-09 2e-08)
Vhv_D i_hv_D 0 pwl(0 0 4.2e-08 0 4.22e-08 3.3 6.2e-08 3.3 6.22e-08 0 8.2e-08 0 8.22e-08 3.3 1.02e-07 3.3 1.022e-07 0 1.22e-07 0 1.222e-07 3.3 1.42e-07 3.3 1.422e-07 0 1.62e-07 0 1.622e-07 3.3 1.82e-07 3.3 1.822e-07 0 2.02e-07 0 2.022e-07 3.3 2.22e-07 3.3 2.222e-07 0 2.42e-07 0 2.422e-07 3.3 2.62e-07 3.3 2.622e-07 0 2.82e-07 0 2.822e-07 3.3 3.02e-07 3.3 3.022e-07 0 3.22e-07 0 3.222e-07 3.3 3.42e-07 3.3 3.422e-07 0 3.62e-07 0 3.622e-07 3.3 3.82e-07 3.3 3.822e-07 0 4.02e-07 0 4.022e-07 3.3 4.22e-07 3.3 4.222e-07 0 4.42e-07 0 4.422e-07 3.3 4.62e-07 3.3 4.622e-07 0 4.82e-07 0 4.822e-07 3.3 5.02e-07 3.3 5.022e-07 0 5.22e-07 0 5.222e-07 3.3 5.42e-07 3.3 5.422e-07 0 5.62e-07 0 5.622e-07 3.3 5.82e-07 3.3 5.822e-07 0 6.02e-07 0 6.022e-07 3.3 6.22e-07 3.3 6.222e-07 0 6.42e-07 0 6.422e-07 3.3)
Vhv_RESET_B i_hv_RESET_B 0 pwl(0 0 6.2e-08 0 6.22e-08 3.3 1.02e-07 3.3 1.022e-07 0 1.42e-07 0 1.422e-07 3.3 1.82e-07 3.3 1.822e-07 0 2.22e-07 0 2.222e-07 3.3 2.62e-07 3.3 2.622e-07 0 3.02e-07 0 3.022e-07 3.3 3.42e-07 3.3 3.422e-07 0 3.82e-07 0 3.822e-07 3.3 4.22e-07 3.3 4.222e-07 0 4.62e-07 0 4.622e-07 3.3 5.02e-07 3.3 5.022e-07 0 5.42e-07 0 5.422e-07 3.3 5.82e-07 3.3 5.822e-07 0 6.22e-07 0 6.222e-07 3.3)
Vhv_SCD i_hv_SCD 0 pwl(0 0 1.02e-07 0 1.022e-07 3.3 1.82e-07 3.3 1.822e-07 0 2.62e-07 0 2.622e-07 3.3 3.42e-07 3.3 3.422e-07 0 4.22e-07 0 4.222e-07 3.3 5.02e-07 3.3 5.022e-07 0 5.82e-07 0 5.822e-07 3.3)
Vhv_SCE i_hv_SCE 0 pwl(0 0 1.82e-07 0 1.822e-07 3.3 3.42e-07 3.3 3.422e-07 0 5.02e-07 0 5.022e-07 3.3)

Xlv o_lv_Q i_lv_CLK i_lv_D i_lv_RESET_B i_lv_SCD i_lv_SCE lvdd 0 sg13g2_sdfrbpq_1
Xhv o_hv_Q i_hv_CLK i_hv_D i_hv_RESET_B i_hv_SCD i_hv_SCE hvdd 0 sg13g2_hv_sdfrbpq_1

.control
tran 5e-11 6.6e-07 uic
wrdata sg13g2_sdfrbpq_1.dat v(o_lv_Q) v(o_hv_Q)
quit
.endc
.end
