* sg13g2_dfrbpq_2: sequential equivalence, thin-oxide vs thick-oxide
.lib /foss/pdks/ihp-sg13g2/libs.tech/ngspice/models/cornerMOSlv.lib mos_tt
.lib /foss/pdks/ihp-sg13g2/libs.tech/ngspice/models/cornerMOShv.lib mos_tt
.include /foss/pdks/ihp-sg13g2/libs.ref/sg13g2_stdcell/spice/sg13g2_stdcell.spice
.include /foss/designs/sg13g2_stdcell_hv/spice/sg13g2_stdcell_hv.spice

Vlvdd lvdd 0 1.2
Vlv_CLK i_lv_CLK 0 pulse(0 1.2 0 2e-10 2e-10 9.8e-09 2e-08)
Vlv_D i_lv_D 0 pwl(0 0 4.2e-08 0 4.22e-08 1.2 6.2e-08 1.2 6.22e-08 0 8.2e-08 0 8.22e-08 1.2 1.02e-07 1.2 1.022e-07 0 1.22e-07 0 1.222e-07 1.2 1.42e-07 1.2 1.422e-07 0 1.62e-07 0 1.622e-07 1.2)
Vlv_RESET_B i_lv_RESET_B 0 pwl(0 0 6.2e-08 0 6.22e-08 1.2 1.02e-07 1.2 1.022e-07 0 1.42e-07 0 1.422e-07 1.2)
Vhvdd hvdd 0 3.3
Vhv_CLK i_hv_CLK 0 pulse(0 3.3 0 2e-10 2e-10 9.8e-09 2e-08)
Vhv_D i_hv_D 0 pwl(0 0 4.2e-08 0 4.22e-08 3.3 6.2e-08 3.3 6.22e-08 0 8.2e-08 0 8.22e-08 3.3 1.02e-07 3.3 1.022e-07 0 1.22e-07 0 1.222e-07 3.3 1.42e-07 3.3 1.422e-07 0 1.62e-07 0 1.622e-07 3.3)
Vhv_RESET_B i_hv_RESET_B 0 pwl(0 0 6.2e-08 0 6.22e-08 3.3 1.02e-07 3.3 1.022e-07 0 1.42e-07 0 1.422e-07 3.3)

Xlv o_lv_Q i_lv_CLK i_lv_D i_lv_RESET_B lvdd 0 sg13g2_dfrbpq_2
Xhv o_hv_Q i_hv_CLK i_hv_D i_hv_RESET_B hvdd 0 sg13g2_hv_dfrbpq_2

.control
tran 5e-11 1.8e-07 uic
wrdata sg13g2_dfrbpq_2.dat v(o_lv_Q) v(o_hv_Q)
quit
.endc
.end
